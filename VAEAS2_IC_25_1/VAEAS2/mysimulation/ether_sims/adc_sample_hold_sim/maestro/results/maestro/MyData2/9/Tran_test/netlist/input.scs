// Point Netlist Generated on: Aug  9 12:41:06 2023
// Generated for: spectre
// Design Netlist Generated on: Aug  9 12:40:39 2023
// Design library name: ether_sims
// Design cell name: adc_sample_hold_sim
// Design view name: schematic_hold
simulator lang=spectre
global 0
parameters temperature=27 clk_freq=125M ampl=300m cload=250f fsignal=14M \
    siddq=0 vdd=2.75
include "gpdk090.scs" section=NN
include "netlist"
simulatorOptions options psfversion="1.4.0" reltol=1e-3 vabstol=1e-6 \
    iabstol=1e-12 temp=27 tnom=27 scalem=1.0 scale=1.0 gmin=1e-12 rforce=1 \
    maxnotes=5 maxwarns=5 digits=5 cols=80 pivrel=1e-3 \
    sensfile="../psf/sens.output" checklimitdest=psf
tran tran stop=1000n write="spectre.ic" writefinal="spectre.fc" \
    annotate=status maxiters=5
finalTimeOP info what=oppoint where=rawfile
modelParameter info what=models where=rawfile
element info what=inst where=rawfile
outputParameter info what=output where=rawfile
designParamVals info what=parameters where=rawfile
primitives info what=primitives where=rawfile
subckts info what=subckts where=rawfile
save OUTP INP SAMPLE HOLD
saveOptions options save=allpub
