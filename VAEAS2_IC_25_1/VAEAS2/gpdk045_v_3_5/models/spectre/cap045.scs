*
simulator lang=spectre
library cap045

section tt
include "gpdk045_mimcap.scs" section=tt3_mim
include "gpdk045_moscap.scs" section=ttcap
include "gpdk045_moscap.scs" section=ttcap_18
endsection tt

section ff
include "gpdk045_mimcap.scs" section=ff3_mim
include "gpdk045_moscap.scs" section=ffcap
include "gpdk045_moscap.scs" section=ffcap_18
endsection ff

section ss
include "gpdk045_mimcap.scs" section=ss3_mim
include "gpdk045_moscap.scs" section=sscap
include "gpdk045_moscap.scs" section=sscap_18
endsection ss

endlibrary cap045
