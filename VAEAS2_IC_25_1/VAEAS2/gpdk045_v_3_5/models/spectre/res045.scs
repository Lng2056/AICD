*
simulator lang=spectre
library res045

section tt
include "gpdk045_resistor.scs" section=tt_res
include "gpdk045_resistor.scs" section=tt_res3
include "gpdk045_inductor.scs" section=tt_ind
endsection tt

section ff
include "gpdk045_resistor.scs" section=ff_res
include "gpdk045_resistor.scs" section=ff_res3
include "gpdk045_inductor.scs" section=ff_ind
endsection ff

section ss
include "gpdk045_resistor.scs" section=ss_res
include "gpdk045_resistor.scs" section=ss_res3
include "gpdk045_inductor.scs" section=ss_ind
endsection ss

endlibrary res045
