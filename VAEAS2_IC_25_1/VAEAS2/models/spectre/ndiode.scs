simulator lang=spectre

inline subckt ndiode (1 2)
parameters area=1e-15 pj=0 rs=3.1961e-8
  r1 (1 3) resistor r=rs/area tc1=2.52e-3
  r2 (3 4) resistor r=rs/area tc1=2.52e-3
  r3 (4 5) resistor r=rs/area tc1=2.52e-3
  r4 (5 6) resistor r=rs/area tc1=2.52e-3
  diode (6 2) ndio area=area pj=pj
ends ndiode
