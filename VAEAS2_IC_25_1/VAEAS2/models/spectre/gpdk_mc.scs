* GPDK Corner Definitions
* This is an example file showing how to define corners
* using model files for individual components as the
* building blocks.

simulator lang=spectre
library gpdk
section mc
*include "mos25gen.scs" section=tt
include "nmos1.scs" section=mc
include "pmos1.scs" section=mc
include "resistor.scs.orig"  section=res
*include "capacitor.scs"  section=cap
include "diode.scs"  section=dio
*include "bipolar.scs"  section=bjt
*include "xjvar_w40.scs"
endsection mc
endlibrary gpdk
