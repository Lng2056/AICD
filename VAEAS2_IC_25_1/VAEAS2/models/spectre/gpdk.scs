* GPDK Corner Definitions
* This is an example file showing how to define corners
* using model files for individual components as the
* building blocks.

simulator lang=spectre
library gpdk

section NN
include "nmos1.scs" section=nom
include "pmos1.scs" section=nom
include "resistor.scs"  section=res
include "capacitor.scs"  section=cap
include "diode.scs"  section=dio
include "bipolar.scs"  section=bjt
endsection NN

section SS
include "nmos1.scs" section=ss
include "pmos1.scs" section=ss
include "resistor.scs"  section=res
include "capacitor.scs"  section=cap
include "diode.scs"  section=dio
include "bipolar.scs"  section=bjt
endsection SS

section FF
include "nmos1.scs" section=ff
include "pmos1.scs" section=ff
include "resistor.scs"  section=res
include "capacitor.scs"  section=cap
include "diode.scs"  section=dio
include "bipolar.scs"  section=bjt
endsection FF

endlibrary gpdk
