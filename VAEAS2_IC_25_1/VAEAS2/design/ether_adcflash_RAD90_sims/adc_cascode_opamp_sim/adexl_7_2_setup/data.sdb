ADE simulation setup
Run mode: Single Run, Sweeps and Corners
Tests:
  ether_adcflash_RAD90_sims:adc_cascode_opamp_sim:1: ether_adcflash_RAD90_sims/adc_cascode_opamp_sim/config_Gain_Vio_CMRR_SR, simulator spectre
    Outputs: AvgVout2
Global variables:
  siddq = 0
  vdd = 2.5
Corners:
  model folders: /servers/esd_noida/anthonys/AnaSimTech/gpdk090_v4.4/libs.oa22/gpdk090/../../models/spectre
  C0_0: temperature=-40; vdd=2.2; gpdk090.scs[NN]
  C0_1: temperature=0; vdd=2.2; gpdk090.scs[NN]
  C0_2: temperature=125; vdd=2.2; gpdk090.scs[NN]
  C0_3: temperature=-40; vdd=2.5; gpdk090.scs[NN]
  C0_4: temperature=0; vdd=2.5; gpdk090.scs[NN]
  C0_5: temperature=125; vdd=2.5; gpdk090.scs[NN]
  C0_6: temperature=-40; vdd=2.8; gpdk090.scs[NN]
  C0_7: temperature=0; vdd=2.8; gpdk090.scs[NN]
  C0_8: temperature=125; vdd=2.8; gpdk090.scs[NN]
  C0_9: temperature=-40; vdd=2.2; gpdk090.scs[SS]
  C0_10: temperature=0; vdd=2.2; gpdk090.scs[SS]
  C0_11: temperature=125; vdd=2.2; gpdk090.scs[SS]
  C0_12: temperature=-40; vdd=2.5; gpdk090.scs[SS]
  C0_13: temperature=0; vdd=2.5; gpdk090.scs[SS]
  C0_14: temperature=125; vdd=2.5; gpdk090.scs[SS]
  C0_15: temperature=-40; vdd=2.8; gpdk090.scs[SS]
  C0_16: temperature=0; vdd=2.8; gpdk090.scs[SS]
  C0_17: temperature=125; vdd=2.8; gpdk090.scs[SS]
  C0_18: temperature=-40; vdd=2.2; gpdk090.scs[FF]
  C0_19: temperature=0; vdd=2.2; gpdk090.scs[FF]
  C0_20: temperature=125; vdd=2.2; gpdk090.scs[FF]
  C0_21: temperature=-40; vdd=2.5; gpdk090.scs[FF]
  C0_22: temperature=0; vdd=2.5; gpdk090.scs[FF]
  C0_23: temperature=125; vdd=2.5; gpdk090.scs[FF]
  C0_24: temperature=-40; vdd=2.8; gpdk090.scs[FF]
  C0_25: temperature=0; vdd=2.8; gpdk090.scs[FF]
  C0_26: temperature=125; vdd=2.8; gpdk090.scs[FF]
Specs:
  ether_adcflash_RAD90_sims:adc_cascode_opamp_sim:1 / AvgVout2: > 1.5
