ADE simulation setup
Run mode: Single Run, Sweeps and Corners
Tests:
  ether_adcflash_RAD90_sims:adc_cascode_opamp_sim:1: ether_adcflash_RAD90_sims/adc_cascode_opamp_sim/config_Gain_Vio_CMRR_SR, simulator spectre
Global variables:
  siddq = 0
  vdd = 2.5
