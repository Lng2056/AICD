//spectreLib4.scs - Models for 4 terminal bipolars

//parameters

simulator lang=spectre

parameters PiRho=2500 PbRho=200 npnbeta=250  pnpbeta=80
//parameters CAP=.8p R_FB=2.5k

//statistics

statistics {
       process {
               vary PiRho     dist=lnorm std=25
               vary PbRho     dist=lnorm std=40
               vary npnbeta   dist=gauss std=20
               vary pnpbeta   dist=gauss std=25
               vary CAP       dist=gauss std=30 percent=yes
	       vary R_FB      dist=gauss std=30 percent=yes
       }
       mismatch {
               vary PiRho dist=lnorm std=19
               vary PbRho dist=lnorm std=3.75
               vary npnbeta dist=gauss std=4
               vary pnpbeta dist=gauss std=6
       }
}

//models
//Use the name trnpn and trpnp for the inline subcircuits
//so you don't need to change the model file name
//in the schematic.

inline subckt trnpn (C B E S)
model npnstat bjt type=npn is=10e-15 bf=npnbeta \
 va=58.7 ik=5.63e-3 rb=565 rbm=86 re=3.2 cje=1.3e-12 pe=0.76 \
 me=0.34 tf=249e-12 cjc=0.8e-12 pc=0.55 mc=0.35 ccs=2.4e-12 \
 ms=0.35 ps=0.53 rc=169 vsubfwd=10

trnpn (C B E S) npnstat
ends trnpn

inline subckt trpnp (C B E S)
model pnpstat bjt type=pnp is=1.2e-16 bf=pnpbeta nf=1 vaf=60 ikf=4e-5 \
 ne=1.5 br=80 nr=1 var=5 ikr=5e-5 isc=0 nc=1.5 rb=100 re=15 rc=30\
 cje=30e-15 vje=.72 mje=.45 tf=5e-10 ptf=40 cjc=60e-15 vjc=.72\
 mjc=.45 xcjc=.9 tr=5e-10 cjs=0 vjs=.99 mjs=.99

trpnp (C B E S) pnpstat
ends trpnp

// No statistical info on MOS devices

;nmos24
model trnmos mos2 type=n vto = 0.775 tox = 400e-10 nsub = 8e+15 \
 xj = 0.15u ld = 0.20u uo = 650 ucrit = 0.62e+5 uexp = 0.125 \
 vmax = 5.1e+4 neff = 4.0 delta = 1.4 rsh = 36 cgso = 1.95e-10 \
 cgdo = 1.95e-10 cj = 195u cjsw = 500p mj = 0.76 mjsw = 0.30 \
 pb = 0.8

;pmos24
model trpmos mos2 type=p vto = -0.75 tox = 400e-10 nsub = 6e+15 \
 xj = 0.05u ld = 0.20u uo = 255 ucrit = 0.86e+5 uexp = 0.29 \
 vmax = 3.0e+4 neff = 2.65 delta = 1.0 rsh = 101 cgso = 1.90e-10 \
 cgdo = 1.90e-10 cj = 250u cjsw = 350p mj = 0.535 mjsw = 0.34 \
 pb = 0.8
