simulator lang=spice
.model nmos nmos
+ level=1 vto=1 kp=16u gamma=1.3 lambda=0.01
+ phi=0.7 pb=0.80 mj=0.5 mjsw=0.3 cgbo=200p cgso=350p cgdo=350p
+ cj=300u cjsw=500p ld=0.8u tox=80n

.model pmos pmos
+ level=1 vto=-1 kp=8u gamma=0.6 lambda=0.02
+ phi=0.6 pb=0.50 mj=0.5 mjsw=0.25 cgbo=200p cgso=350p cgdo=350p
+ cj=150u cjsw=400p ld=0.8u tox=80n

.model trdiode d is=1e-16 cjo=1e-12 vj=.62 n=.47

.model trnmos nmos level=3 kp=16u gamma=1.3
+ phi=0.7 pb=0.80 mj=0.5 mjsw=0.3 cgbo=200p cgso=350p cgdo=350p
+ cj=300u cjsw=500p ld=0.8u tox=80n

;.model trnpn npn is=1.5e-16 bf=250 nf=1 vaf=150 ikf=7e-4 ne=1.5
;+ br=2 nr=1 var=5 ikr=3e-3 isc=0 nc=1.5 rb=600 re=3 rc=75
;+ cje=40e-15 vje=.91 mje=.35 tf=20e-12 ptf=10 cjc=40e-15 vjc=.72
;+ mjc=.45 xcjc=.25 tr=20e-11 cjs=75e-15 vjs=.62 mjs=.47
;+ eg=1.12 fc=.5

.model trnpn npn is=10e-13 bf=250
+ va=58.7 ik=5.63e-3 rb=565 rbm=86 re=3.2 cje=0.25e-12 pe=0.76
+ me=0.34 tf=249e-12 cjc=0.34e-12 pc=0.55 mc=0.35 ccs=2.4e-12
+ ms=0.35 ps=0.53 rc=169

;.model trnpn_beta npn is=10e-13 bf=beta
;+ va=58.7 ik=5.63e-3 rb=665 rbm=86 re=3.2 cje=0.25e-12 pe=0.76
;+ me=0.34 tf=249e-12 cjc=0.34e-12 pc=0.55 mc=0.35 ccs=2.4e-12
;+ ms=0.35 ps=0.53 rc=169

;.model trnpn_mc npn is=10e-13 bf=GAUSS(beta,beta*0.25,1)
;+ va=58.7 ik=5.63e-3 rb=665 rbm=86 re=3.2 cje=0.25e-12 pe=0.76
;+ me=0.34 tf=249e-12 cjc=0.34e-12 pc=0.55 mc=0.35 ccs=2.4e-12
;+ ms=0.35 ps=0.53 rc=169

.model trpmos pmos level=3 vto=-1 kp=8u gamma=0.6
+ phi=0.6 pb=0.50 mj=0.5 mjsw=0.25 cgbo=200p cgso=350p cgdo=350p
+ cj=150u cjsw=400p ld=0.8u tox=80n

.model trpnp pnp is=1.2e-16 bf=80 nf=1 vaf=60 ikf=4e-5 ne=1.5
+ br=80 nr=1 var=5 ikr=5e-5 isc=0 nc=1.5 rb=100 re=15 rc=30
+ cje=30e-15 vje=.72 mje=.45 tf=5e-10 ptf=40 cjc=60e-15 vjc=.72
+ mjc=.45 xcjc=.9 tr=5e-10 cjs=0 vjs=.99 mjs=.99
+ eg=1.17 fc=.5

;.model trpnp pnp is=10e-13 bf=60 va=43.1 ik=0.206e-3 rb=245 rbm=64.3
;+ re=33.8 cje=0.16e-12 pe=0.5 me=0.26 tf=36e-9 cjc=0.72e-12 pc=0.58
;+ mc=0.34 ccs=2.5e-12 ps=0.53 ms=0.35 rc=276

simulator lang=spectre
