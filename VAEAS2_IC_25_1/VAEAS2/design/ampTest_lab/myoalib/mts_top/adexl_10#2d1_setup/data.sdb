ADE simulation setup
Run mode: Single Run, Sweeps and Corners
Tests:
  myoalib:mts_top:1: myoalib/mts_top/config, simulator spectre
Global variables:
  CAP = 5p
  R_FB = 2.5k
