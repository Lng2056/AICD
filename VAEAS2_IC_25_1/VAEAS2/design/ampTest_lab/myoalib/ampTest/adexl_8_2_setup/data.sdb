ADE simulation setup
Run mode: Monte Carlo Sampling
Tests:
  AC_Test: myoalib/ampTest/schematic, simulator spectre
    Outputs: mag; phase; BW; beta; resvalue
Global variables:
  R1_value = 20K
  CAP = .8p
  R_FB = 2.5K
Specs:
  AC_Test / BW: > 25M
Monte Carlo Sampling options: mcmethod=all, mcnumpoints=50
