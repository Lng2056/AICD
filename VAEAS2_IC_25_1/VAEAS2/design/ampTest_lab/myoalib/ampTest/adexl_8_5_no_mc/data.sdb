ADE simulation setup
Run mode: Single Run, Sweeps and Corners
Tests:
  AC_Test: myoalib/ampTest/schematic, simulator spectre
    Outputs: mag; phase; BW; beta; resvalue
  myoalib:ampTest_tran:1: myoalib/ampTest_tran/schematic, simulator spectre
    Outputs: tdr; tdf
Global variables:
  R1_value = 20K
  CAP = .8p
  R_FB = 2.5K
Specs:
  AC_Test / BW: > 25M
  myoalib:ampTest_tran:1 / tdr: range 3n to 10n
  myoalib:ampTest_tran:1 / tdf: range 2n to 6n
