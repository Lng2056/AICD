ADE simulation setup
Run mode: Single Run, Sweeps and Corners
Tests:
  AC_Test: myoalib/ampTest/schematic, simulator spectre
    Variables: R_FB = 2.5K; R1_value = 20K; CAP = .8p
    Outputs: mag; phase; BW; beta; resvalue
Global variables:
  R1_value = 20K
  CAP = .8p
  R_FB = 2.5K
Specs:
  AC_Test / BW: > 25M
