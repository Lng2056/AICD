ADE simulation setup
Test AC_Test: myoalib/ampTest/schematic, simulator spectre
  Models: MCmodels.scs
  Variables: R_FB = 2.5K; R1_value = 20K; CAP = .8p
  Temperature: 27
  Analysis dc: (saves the operating point)
  Analysis ac: start=100 stop=150M dec=10
  Output mag = dB20(VF("/out"))
  Output phase = phase(VF("/out"))
  Output BW = bandwidth(mag(VF("/out")) 3 "low")
  Output beta = MP("/I8/Q0" "bf")
  Output resvalue = OP("/I8/R0" "res")
  Signals: /out
Run mode: Single Run, Sweeps and Corners
Global variables:
  R1_value = 20K
  CAP = .8p
  R_FB = 2.5K
Specs:
  AC_Test / BW: > 25M
