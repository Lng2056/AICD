// Verilog-AMS netlist generated by the AMS netlister, version ICOA5.2.51.500.7.
// Cadence Design Systems, Inc.

`include "disciplines.vams"

module top_sim (  );

wire [4:0] RXD_1;
wire [4:0] PHY_0;
wire [1:0] TX_SLP_TRIM_1;
wire [1:0] TX_AMP_TRIM_0;
wire [4:0] RXD_0;
wire [3:0] BGTRIM;
wire [1:0] TX_SLP_TRIM_0;
wire [4:0] PHY_1;
wire [1:0] TX_AMP_TRIM_1;
wire [4:0] TXD_0;
wire [4:0] TXD_1;

top (*
integer library_binding = "ether";
 *)
I0 ( .TXC( TXC_0 ), .RXDV(
RXDV_0 ), .ANLG_TST( ANLG_TST_0 ), .LEDL( LEDL_0 ), .LEDR( LEDR_0 ), .TXER(
TXER_0 ), .RXC( RXC_0 ), .XTAL25( XTAL25 ), .SIDDQ( SIDDQ ), .TPON(
TPON_0 ), .ANDIS( ANDIS_0 ), .B10_DIS( B10_DIS_0 ), .SCAN_MODE(
SCAN_EN_0 ), .SCAN_ENABLE( GND ), .TXEN( TXEN_0 ), .MDIO_IN( MDIO_IN ),
.LEDT( LEDT_0 ), .TX_SLP_TRIM( TX_SLP_TRIM_0[1:0] ), .LEDS( LEDS_0 ),
.B100_DIS( B100_DIS_0 ), .VDDRX( VDDRX ), .MDINT( MDINT_0 ), .LEDC(
LEDC_0 ), .RBIAS_SENSE( RB ), .RBIAS( RB ), .TPOP( TPOP_0 ), .PHY(
PHY_0[4:0] ), .LEDD( LEDD_0 ), .RESETN( RESETN_0 ), .VDD( VDD ), .TRISTATE(
TRISTATE_0 ), .SYMBOL_MODE( SYMBOL_MODE_0 ), .TPIP( TPIP_0 ), .COL(
COL_0 ), .DISABLE10( DISABLE10 ), .VDDTX( VDDTX ), .VDDA_250( VDDA ),
.GNDRX( GNDRX ), .VDDA_160( VDDA ), .GNDA_160( GNDA ), .GNDA_250( GNDA ),
.MDIO_OE( MDIO_OE_0 ), .MDC( MDC ), .TPIN( TPIN_0 ), .TX_AMP_TRIM(
TX_AMP_TRIM_0[1:0] ), .TXD( TXD_0[4:0] ), .DISABLE100( DISABLE100 ), .GNDTX(
GNDTX ), .GND( GND ), .MDIO_OUT( MDIO_OUT_0 ), .BGTRIM( BGTRIM[3:0] ),
.RXD( RXD_0[4:0] ), .RXER( RXER_0 ), .CRS( CRS_0 ) );

clkbuf_16x_hv (*
integer library_binding = "ether";
 *)
I163 ( .Y(
net209 ), .A( FIBSEL_0 ) );
clkbuf_16x_hv (*
integer library_binding = "ether";
 *)
I164 ( .Y(
net207 ), .A( FIBSEL_1 ) );
clkbuf_16x_hv (*
integer library_binding = "ether";
 *)
I165 ( .Y(
net205 ), .A( SIDDQ_0 ) );
clkbuf_16x_hv (*
integer library_binding = "ether";
 *)
I166 ( .Y(
net203 ), .A( SIDDQ_1 ) );

PE68515_ssr (*
integer library_binding = "ether_sims";
 *)
I144 ( .Pminus(
net092 ), .Pplus( net097 ), .Sminus( net0122 ), .cnt_chip( VDDTX ), .Splus(
net065 ), .cnt_line( VDDRX ) );

pkg_80LD (*
integer library_binding = "ether_sims";
 *)
I6 ( .CH_POS(
TPOP_0 ), .PC_NEG( net094 ), .PC_POS( net0103 ), .CH_NEG( TPON_0 ) );
pkg_80LD (*
integer library_binding = "ether_sims";
 *)
I50 ( .CH_POS(
net068 ), .PC_NEG( TPIN_0 ), .PC_POS( TPIP_0 ), .CH_NEG( net069 ) );

testcase (*
integer library_binding = "ether_sims";
 *)
tc ( .TX_AMP_TRIM_0(
TX_AMP_TRIM_0[1:0] ), .TXEN_1( TXEN_1 ), .LEDR_1( LEDR_1 ), .SCANCLK_0(
net0156 ), .MDINT_1( MDINT_1 ), .RESETN_1( RESETN_1 ), .XTAL25( XTAL25 ),
.LEDR_0( LEDR_0 ), .TX_AMP_TRIM_1( TX_AMP_TRIM_1[1:0] ), .SIDDQ( SIDDQ ),
.CRS_1( CRS_1 ), .CRS_0( CRS_0 ), .B100_DIS_1( B100_DIS_1 ), .RXC_0(
RXC_0 ), .COL_1( COL_1 ), .SCAN_EN_0( SCAN_EN_0 ), .MDIO_OUT_0(
MDIO_OUT_0 ), .MDIO_OE_1( MDIO_OE_1 ), .B100_DIS_0( B100_DIS_0 ), .MDIO_IN(
MDIO_IN ), .LEDL_1( LEDL_1 ), .TRISTATE_0( TRISTATE_0 ), .MDIO_OE_0(
MDIO_OE_0 ), .RXC_1( RXC_1 ), .LEDS_1( LEDS_1 ), .RXER_1( RXER_1 ), .RXD_1(
RXD_1[4:0] ), .LEDC_0( LEDC_0 ), .TRISTATE_1( TRISTATE_1 ), .TXC_0(
TXC_0 ), .LEDT_1( LEDT_1 ), .ANDIS_1( ANDIS_1 ), .RESETN_0( RESETN_0 ),
.COL_0( COL_0 ), .LEDT_0( LEDT_0 ), .FIBSEL_1( FIBSEL_1 ), .RXDV_0(
RXDV_0 ), .TX_SLP_TRIM_0( TX_SLP_TRIM_0[1:0] ), .TXD_0( TXD_0[4:0] ),
.LEDD_0( LEDD_0 ), .PHY_1( PHY_1[4:0] ), .PHY_0( PHY_0[4:0] ), .DISABLE10(
DISABLE10 ), .RXD_0( RXD_0[4:0] ), .LEDL_0( LEDL_0 ), .TX_SLP_TRIM_1(
TX_SLP_TRIM_1[1:0] ), .B10_DIS_0( B10_DIS_0 ), .MDIO_OUT_1( MDIO_OUT_1 ),
.ANDIS_0( ANDIS_0 ), .MDINT_0( MDINT_0 ), .MDC( MDC ), .RXER_0( RXER_0 ),
.RXDV_1( RXDV_1 ), .TXER_0( TXER_0 ), .SCAN_EN_1( SCAN_EN_1 ), .TXC_1(
TXC_1 ), .LEDS_0( LEDS_0 ), .SIDDQ_1( SIDDQ_1 ), .SCANCLK_1( SCANCLK_1 ),
.SIDDQ_0( SIDDQ_0 ), .FIBSEL_0( FIBSEL_0 ), .DISABLE100( DISABLE100 ),
.LEDD_1( LEDD_1 ), .LEDC_1( LEDC_1 ), .TXER_1( TXER_1 ), .TXD_1(
TXD_1[4:0] ), .TXEN_0( TXEN_0 ), .BGTRIM( BGTRIM[3:0] ), .B10_DIS_1(
B10_DIS_1 ) );

tline #(.td(45p), .z0(50)) (*
integer library_binding = "analogLib";

 *)
T11 ( net067, cds_globals.\gnd! , net0103, cds_globals.\gnd!  );
tline #(.td(45p), .z0(50)) (*
integer library_binding = "analogLib";

 *)
T15 ( cds_globals.\gnd! , net097, cds_globals.\gnd! , net0221 );
tline #(.td(45p), .z0(50)) (*
integer library_binding = "analogLib";

 *)
T14 ( cds_globals.\gnd! , net0221, cds_globals.\gnd! , net094 );
tline #(.td(45p), .z0(50)) (*
integer library_binding = "analogLib";

 *)
T9 ( cds_globals.\gnd! , net085, cds_globals.\gnd! , net065 );
tline #(.td(45p), .z0(50)) (*
integer library_binding = "analogLib";

 *)
T5 ( cds_globals.\gnd! , net069, cds_globals.\gnd! , net085 );
tline #(.td(45p), .z0(50)) (*
integer library_binding = "analogLib";

 *)
T18 ( net068, cds_globals.\gnd! , net066, cds_globals.\gnd!  );
tline #(.td(45p), .z0(50)) (*
integer library_binding = "analogLib";

 *)
T17 ( net066, cds_globals.\gnd! , net0122, cds_globals.\gnd!  );
tline #(.td(45p), .z0(50)) (*
integer library_binding = "analogLib";

 *)
T16 ( net092, cds_globals.\gnd! , net067, cds_globals.\gnd!  );

vsource #(.type("dc"), .dc(cds_globals.vdd_nom)) (*
integer
library_binding = "analogLib";
 *)
V12 ( VDDA, cds_globals.\gnd!  );
vsource #(.type("dc"), .dc(0)) (*
integer library_binding
 = "analogLib";
 *)
V13 ( GNDRX, cds_globals.\gnd!  );
vsource #(.type("dc"), .dc(cds_globals.vdd_1p0)) (*
integer
library_binding = "analogLib";
 *)
V14 ( VDD, cds_globals.\gnd!  );
vsource #(.type("dc"), .dc(cds_globals.vdd_nom)) (*
integer
library_binding = "analogLib";
 *)
V15 ( VDDRX, cds_globals.\gnd!  );
vsource #(.type("dc"), .dc(cds_globals.vdd_nom)) (*
integer
library_binding = "analogLib";
 *)
V16 ( VDDTX, cds_globals.\gnd!  );
vsource #(.type("dc"), .dc(0)) (*
integer library_binding
 = "analogLib";
 *)
V17 ( GNDA, cds_globals.\gnd!  );
vsource #(.type("dc"), .dc(0)) (*
integer library_binding
 = "analogLib";
 *)
V21 ( GNDTX, cds_globals.\gnd!  );
vsource #(.type("dc"), .dc(0)) (*
integer library_binding
 = "analogLib";
 *)
V22 ( GND, cds_globals.\gnd!  );
vsource #(.type("dc"), .dc(cds_globals.vdd_nom)) (*
integer
library_binding = "analogLib";
 *)
V2 ( cds_globals.\vdda! ,
cds_globals.\gnd!  );
vsource #(.type("dc"), .dc(0)) (*
integer library_binding
 = "analogLib";
 *)
V3 ( cds_globals.\vss! , cds_globals.\gnd!  );
vsource #(.type("dc"), .dc(0)) (*
integer library_binding
 = "analogLib";
 *)
V4 ( cds_globals.\VSS! , cds_globals.\gnd!  );

resistor #(.r(12.1K)) (*
integer library_binding = "analogLib";
 *)

R58 ( GNDA, RB );
resistor #(.r(50)) (*
integer library_binding = "analogLib";
 *)
R54
 ( VDDRX, net066 );
resistor #(.r(50)) (*
integer library_binding = "analogLib";
 *)
R52
 ( net067, VDDTX );
resistor #(.r(50)) (*
integer library_binding = "analogLib";
 *)
R55
 ( net085, VDDRX );
resistor #(.r(50)) (*
integer library_binding = "analogLib";
 *)
R57
 ( VDDTX, net0221 );

endmodule
