ADE simulation setup
Test User_test: ether_sims/adc_sample_hold_sim/schematic, simulator spectre
  Models: /servers/esd_noida/anthonys/AnaSimTech/gpdk090_v4.4/libs.oa22/gpdk090/../../models/spectre/gpdk090.scs[NN]
  Temperature: 27
  Analysis tran: stop=200n
  Signals: /OUTP, /INP
Test Tran_test: ether_sims/adc_sample_hold_sim/schematic_hold, simulator spectre
  Models: /servers/esd_noida/anthonys/AnaSimTech/gpdk090_v4.4/libs.oa22/gpdk090/../../models/spectre/gpdk090.scs[NN]
  Temperature: 27
  Analysis tran: stop=1000n
  Output Droop Rate = ((value(VT("/OUTP") 2.5e-07) - value(VT("/OUTP") 7.5e-07)) * 2)
  Signals: /OUTP, /INP, /SAMPLE, /HOLD
Test AC_test: ether_sims/adc_sample_hold_sim/schematic_sample, simulator spectre
  Models: /servers/esd_noida/anthonys/AnaSimTech/gpdk090_v4.4/libs.oa22/gpdk090/../../models/spectre/gpdk090.scs[NN]
  Temperature: 27
  Analysis ac: start=1 stop=10G dec=20
  Output BW = bandwidth(mag(VF("/OUTP")) 3 "low")
  Output Gain = value(mag(VF("/OUTP")) 1000)
  Signals: /OUTP
Run mode: Single Run, Sweeps and Corners
Global variables:
  ampl = 300m
  clk_freq = 125M
  cload = 250f
  fsignal = 10M 12M 14M
  vdd = {Center/Span%}Auto:2.5:3:20{Center/Span%}
  siddq = 0
Specs:
  Tran_test / Droop Rate: < 1u
  AC_test / Gain: target 900m, tolerance 1%
  AC_test / BW: > 215M
