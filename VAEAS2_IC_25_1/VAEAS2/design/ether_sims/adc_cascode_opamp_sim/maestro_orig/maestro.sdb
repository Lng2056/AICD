ADE simulation setup
Run mode: Single Run, Sweeps and Corners
Tests:
  User_test: ether_sims/adc_sample_hold_sim/schematic, simulator spectre
  Tran_test: ether_sims/adc_sample_hold_sim/schematic_hold, simulator spectre
    Outputs: Droop Rate
  AC_test: ether_sims/adc_sample_hold_sim/schematic_sample, simulator spectre
    Outputs: BW; Gain
Global variables:
  ampl = 300m
  clk_freq = 125M
  cload = 250f
  fsignal = 10M 12M 14M
  vdd = {Center/Span%}Auto:2.5:3:20{Center/Span%}
  siddq = 0
Specs:
  Tran_test / Droop Rate: < 1u
  AC_test / Gain: target 900m, tolerance 1%
  AC_test / BW: > 215M
