// Verilog-AMS cds_globals module for top-level cell:
//      ether_sims/top_sim.
// Generated by AMS.
// Cadence Design Systems, Inc.

`include "disciplines.vams"

module cds_globals;

// Global Signals
    wire \vdda! ;
    wire \VSS! ;
    wire \vss! ;
    electrical \gnd! ;
    ground \gnd! ;

// Design Variables
    dynamicparam real vdd_1p0 = 1.0;
    dynamicparam real vdd_nom = 2.5;
    dynamicparam real freq = 4.1667E+8;
    dynamicparam real fvco = 2.5E+9;
    dynamicparam real freg = 416.7M;
    dynamicparam real R = 100;

endmodule
