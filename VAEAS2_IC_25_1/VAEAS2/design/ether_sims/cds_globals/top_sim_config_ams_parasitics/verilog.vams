// Verilog-AMS cds_globals module for top-level cell:
//      ether_sims/top_sim.
// Generated by AMS.
// Cadence Design Systems, Inc.

`include "disciplines.vams"

module cds_globals;

// Global Signals
    electrical \gnd! ;
    ground \gnd! ;
    wire \VDD_2p5! ;
    wire \VDD_1p0! ;
    wire \VDD! ;
    wire \VSS! ;

// Design Variables
    dynamicparam real fvco = 2.5E+09;
    dynamicparam real R = 100;
    dynamicparam real freq = 4.16667E+08;
    dynamicparam real vdd_1p0 = 1.0;
    dynamicparam real vdd_nom = 2.5;

endmodule
