// Verilog-AMS cds_globals module for top-level cell:
//      ether_sims/pll_250MHz_ams_sim.
// Generated by AMS.
// Cadence Design Systems, Inc.

`include "disciplines.vams"

module cds_globals;

// Global Signals
    wire \VDD! ;
    wire \VSS! ;
    electrical \gnd! ;
    ground \gnd! ;

// Design Variables
    dynamicparam real VMULT = 1;
    dynamicparam real freg = 4.16667E+08;
    dynamicparam real fvco = 2.5E+09;

endmodule
