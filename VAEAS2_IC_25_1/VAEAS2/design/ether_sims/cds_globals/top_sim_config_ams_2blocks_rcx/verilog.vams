// Verilog-AMS cds_globals module for top-level cell:
//      ether_sims/top_sim.
// Generated by AMS.
// Cadence Design Systems, Inc.

`include "disciplines.vams"

module cds_globals;

endmodule
