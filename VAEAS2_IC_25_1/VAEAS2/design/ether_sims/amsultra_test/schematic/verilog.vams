// Verilog-AMS netlist generated by the AMS netlister, version 5.10.41_USR1.29.
// Cadence Design Systems, Inc.

`include "disciplines.vams"

module amsultra_test ( XTAL25_test_1 );

output   XTAL25_test_1;

INVX1_inh #(.ieIO("output"), .d2a_tr("100p"), .a2d_v0("0.5"), .d2a_tf("100p"),
 .a2d_tx("100p"), .a2d_v1("0.8"), .d2a_vh("1"))
 (* integer library_binding = "gsclib090";
    integer cds_net_set[0:1]= {"VSS","VDD"};
    integer VSS = "GND";
    integer VDD = "VDD";  *)
  I18 ( .Y( net015 ), .A( XTAL25_INTEST_1 ) );

INVX4 #(.ieIO("output"), .d2a_tr("100p"), .a2d_v0("0.5"), .d2a_tf("100p"),
 .a2d_tx("100p"), .a2d_v1("0.8"), .d2a_vh("1"))
 (* integer library_binding = "gsclib090";
    integer cds_net_set[0:1]= {"VSS","VDD"};
    integer VSS = "GND";
    integer VDD = "VDD";  *)
  I27 ( .Y( net07 ), .A( net015 ) );

INVX8 #(.d2a_tr("100p"), .ieIO("input"), .a2d_v0("0.5"), .d2a_tf("100p"),
 .a2d_v1("0.8"), .d2a_vh("1"), .a2d_tx("100p"))
 (* integer library_binding = "gsclib090";
    integer cds_net_set[0:1]= {"VDD","VSS"};
    integer VDD = "VDD";
    integer VSS = "GND";  *)
  I30 ( .Y( net013 ), .A( net07 ) );
INVX8 #(.d2a_tr("100p"), .ieIO("output"), .a2d_v0("0.5"), .d2a_tf("100p"),
 .d2a_vh("1"), .a2d_tx("100p"), .a2d_v1("0.8"))
 (* integer library_binding = "gsclib090";
    integer cds_net_set[0:1]= {"VSS","VDD"};
    integer VSS = "GND";
    integer VDD = "VDD";  *)
  I29 ( .Y( XTAL25_test_1 ), .A( net013 ) );
INVX8 #(.d2a_tr("100p"), .ieIO("output"), .a2d_v0("0.5"), .d2a_tf("100p"),
 .a2d_tx("100p"), .a2d_v1("0.8"), .d2a_vh("1"))
 (* integer library_binding = "gsclib090";
    integer cds_net_set[0:1]= {"VDD","VSS"};
    integer VDD = "VDD";
    integer VSS = "GND";  *)
  I28 ( .Y( XTAL25_test_1 ), .A( net013 ) );

vsource #(.type("dc"), .dc(0))  (*
integer library_binding = "analogLib";  *) V3 ( GND,
cds_globals.\gnd!  );
vsource #(.type("dc"), .dc(1))  (*
integer library_binding = "analogLib";  *) V2 ( VDD,
cds_globals.\gnd!  );
vsource #(.type("dc"), .dc(0))  (*
integer library_binding = "analogLib";  *) V21 ( GNDTX,
cds_globals.\gnd!  );
vsource #(.type("dc"), .dc(2.5))  (*
integer library_binding = "analogLib";  *) V16 ( VDDTX,
cds_globals.\gnd!  );
vsource #(.type("dc"), .dc(1))  (*
integer library_binding = "analogLib";  *) V14 ( cds_globals.\VDD! ,
cds_globals.\gnd!  );
vsource #(.type("dc"), .dc(0))  (*
integer library_binding = "analogLib";  *) V22 ( cds_globals.\GND! ,
cds_globals.\gnd!  );

inv_16x_hv #(.d2a_tr("100p"), .ieIO("output"), .a2d_v0("0.5"), .d2a_tf("100p"),
 .d2a_vh("2.5"), .a2d_v1("0.8"), .a2d_tx("100p"))
 (* integer library_binding = "VFS_AMS_PHY180";
    integer cds_net_set[0:1]= {"DVDD","DVSS"};
    integer DVDD = "VDDTX";
    integer DVSS = "GNDTX";  *)
  I4 ( .Y( OUT ), .A( net19 ) );

inv_8x_hv #(.d2a_tr("100p"), .ieIO("output"), .a2d_v0("0.5"), .d2a_tf("100p"),
 .d2a_vh("2.5"), .a2d_v1("0.8"), .a2d_tx("100p"))
 (* integer library_binding = "VFS_AMS_PHY180";
    integer cds_net_set[0:1]= {"DVDD","DVSS"};
    integer DVDD = "VDDTX";
    integer DVSS = "GNDTX";  *)
  I2 ( .Y( net19 ), .A( net21 ) );

inv_3x_hv #(.d2a_tr("100p"), .ieIO("output"), .a2d_v0("0.5"), .d2a_tf("100p"),
 .d2a_vh("2.5"), .a2d_v1("0.8"), .a2d_tx("100p"))
 (* integer library_binding = "VFS_AMS_PHY180";
    integer cds_net_set[0:1]= {"DVSS","DVDD"};
    integer DVSS = "GNDTX";
    integer DVDD = "VDDTX";  *)
  I1 ( .Y( net21 ), .A( net23 ) );

inv_1x_hv #(.d2a_tr("100p"), .ieIO("output"), .a2d_v0("0.5"), .d2a_tf("100p"),
 .a2d_v1("0.8"), .a2d_tx("100p"), .d2a_vh("2.5"))
 (* integer library_binding = "VFS_AMS_PHY180";
    integer cds_net_set[0:1]= {"DVSS","DVDD"};
    integer DVSS = "GNDTX";
    integer DVDD = "VDDTX";  *)
  I0 ( .Y( net23 ), .A( XTAL25_INTEST ) );

vsource #(.delay(0), .type("pulse"), .period(40n), .fundname("nameREF"),
 .width(19.9n), .val0(0), .rise(100p), .val1(1), .fall(100p))  (*
integer library_binding = "analogLib";  *) V1 ( XTAL25_INTEST_1,
cds_globals.\gnd!  );
vsource #(.delay(0), .type("pulse"), .period(40n), .fundname("nameREF"),
 .width(19.9n), .val0(0), .rise(100p), .val1(2.5), .fall(100p))  (*
integer library_binding = "analogLib";  *) V6 ( XTAL25_INTEST,
cds_globals.\gnd!  );

endmodule
