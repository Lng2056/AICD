// Verilog-AMS netlist generated by the AMS netlister, version 5.10.41.155.
// Cadence Design Systems, Inc.

`include "disciplines.vams"

module pll_vco_250MHz_sim ( VCO_CLK );

output [10:0]  VCO_CLK;

PLL_VCO_250MHZ  (* integer library_binding = "VFS_AMS_PHY180";  *) I0
 ( .VCO_CLK_PH( VCO_CLK[10:0] ), .IEXT_100u( net15 ), .VDD( VDD ), .PD(
PowerDown ), .VSS( VSS ), .Vcontrol( Vcntl ) );

vsource #(.wave({100n,700.0m,200n,700.0m,201n,1.2,300n,1.2,301n,1.7}),
 .dc(0), .type("pwl"))  (* integer library_binding = "analogLib";  *)
V0 ( Vcntl, cds_globals.\gnd!  );

capacitor #(.c(200f))
 (* integer library_binding = "analogLib";
    integer elaboration_binding = "PCAP[10:0]"; *)
  PCAP_10 ( VCO_CLK[10], cds_globals.\gnd!  ),
  PCAP_9 ( VCO_CLK[9], cds_globals.\gnd!  ),
  PCAP_8 ( VCO_CLK[8], cds_globals.\gnd!  ),
  PCAP_7 ( VCO_CLK[7], cds_globals.\gnd!  ),
  PCAP_6 ( VCO_CLK[6], cds_globals.\gnd!  ),
  PCAP_5 ( VCO_CLK[5], cds_globals.\gnd!  ),
  PCAP_4 ( VCO_CLK[4], cds_globals.\gnd!  ),
  PCAP_3 ( VCO_CLK[3], cds_globals.\gnd!  ),
  PCAP_2 ( VCO_CLK[2], cds_globals.\gnd!  ),
  PCAP_1 ( VCO_CLK[1], cds_globals.\gnd!  ),
  PCAP_0 ( VCO_CLK[0], cds_globals.\gnd!  );

vsource #(.delay(1n), .type("pulse"), .period(2), .width(1), .val0(0),
 .dc(cds_globals.vdd), .rise(100p), .val1(cds_globals.vdd), .fall(100p))
 (* integer library_binding = "analogLib";  *) V5 ( VDD,
cds_globals.\gnd!  );

vsource #(.type("dc"), .dc(0))  (*
integer library_binding = "analogLib";  *) V2 ( PowerDown,
cds_globals.\gnd!  );
vsource #(.type("dc"), .dc(0))  (*
integer library_binding = "analogLib";  *) V1 ( VSS,
cds_globals.\gnd!  );

isource #(.type("dc"), .dc(100u))  (*
integer library_binding = "analogLib";  *) V4 ( net15, VSS );

endmodule
