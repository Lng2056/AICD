// Verilog-AMS netlist generated by the AMS netlister, version 5.10.41_USR1.4.
// Cadence Design Systems, Inc.

`include "disciplines.vams"

module pkg_80LD ( CH_POS,PC_NEG,PC_POS,CH_NEG );

input   CH_POS;
output   PC_NEG;
output   PC_POS;
input   CH_NEG;

pkg_80LD_QFP  (* integer library_binding = "VFS_AMS_PHY180_sims";  *)
I0 ( net44, net43, net42, net41, net40, net39, net38, net37, net36,
net35, net34, net33, net32, net31, net30, net29, net28, net27, net26,
net25, net125, net126, net127, net128, net129, net130, net131, net132,
net133, net134, net135, net136, net137, net138, net139, net140, net141,
net142, net143, net144, net84, net83, net82, net81, net80, net79,
net78, net77, net76, net75, net74, CH_NEG, CH_POS, net71, net70, net69,
net68, net67, net66, net65, net85, net86, net87, net88, net89, net90,
net91, net92, net93, net94, net95, net96, net97, net98, net99, net100,
net101, net102, net103, net104, net64, net63, net62, net61, net60,
net59, net58, net57, net56, net55, net54, net53, net52, net51, net50,
net49, net48, net47, net46, net45, net105, net106, net107, net108,
net109, net110, net111, net112, net113, net114, net115, net116, net117,
net118, net119, net120, net121, net122, net123, net124, net24, net23,
net22, net21, net20, net19, net18, net17, net16, net15, net14, PC_NEG,
PC_POS, net11, net10, net9, net8, net7, net6, net5, net145, net146,
net147, net148, net149, net150, net151, net152, net153, net154, net155,
net156, net157, net158, net159, net160, net161, net162, net163, net164,
cds_globals.\gnd!  );

endmodule
