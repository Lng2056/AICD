ADE simulation setup
Test AC_test_1: multest_devchk/adc_cascode_opamp_sim/sch_dc_ac_2, simulator spectre
  Models: /servers/esd_noida/saidarsh/VAEAS2/gpdk045_v_3_5/models/spectre/gpdk045.scs[mc]
  Variables: temperature = 27; siddq = 0; vdd = 2.5; vin_ac = 1.25
  Temperature: 27
  Analysis ac: start=1 stop=10G dec=20
  Analysis dc: (saves the operating point)
  Output AC_gain_1k = value(mag(VF("/OUT_AC_3BIT")) 1000)
  Output AC_BW_3dB = bandwidth(mag(VF("/OUT_AC_3BIT")) 3 "low")
  Signals: /OUT_AC_3BIT
