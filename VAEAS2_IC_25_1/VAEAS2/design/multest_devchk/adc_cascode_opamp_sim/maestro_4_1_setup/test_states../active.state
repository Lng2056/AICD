ADE simulation setup
Test Tran_test: ether_sims/adc_sample_hold_sim/schematic_hold, simulator spectre
  Models: gpdk090.scs[NN]
  Temperature: 27
  Analysis tran: stop=1000n
  Output Droop Rate = ((value(VT("/OUTP") 2.5e-07) - value(VT("/OUTP") 7.5e-07)) * 2)
  Signals: /OUTP, /INP, /SAMPLE, /HOLD
Test User_test: ether_sims/adc_sample_hold_sim/schematic, simulator spectre
  Models: gpdk090.scs[NN]
  Temperature: 27
  Analysis tran: stop=200n
  Signals: /OUTP, /INP
Test AC_test: ether_sims/adc_sample_hold_sim/schematic_sample, simulator spectre
  Models: gpdk090.scs[NN]
  Temperature: 27
  Analysis ac: start=1 stop=10G dec=20
  Output BW = bandwidth(mag(VF("/OUTP")) 3 "low")
  Output Gain = value(mag(VF("/OUTP")) 1000)
  Signals: /OUTP
