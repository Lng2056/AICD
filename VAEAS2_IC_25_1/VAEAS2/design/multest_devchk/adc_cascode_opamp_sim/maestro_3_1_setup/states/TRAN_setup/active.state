ADE simulation setup
Test AC_test: multest_devchk/adc_cascode_opamp_sim/sch_dc_ac_2, simulator spectre
  Models: /servers/esd_noida/saidarsh/VAEAS2/gpdk045_v_3_5/models/spectre/gpdk045.scs[mc]
  Variables: temperature = 27; siddq = 0; vdd = 2.5; vin_ac = 1.0
  Temperature: 27
  Analysis ac: start=1 stop=10G dec=20
  Analysis dc: (saves the operating point)
  Output AC_gain_1k = value(mag(VF("/OUT_AC_3BIT")) 1000)
  Output AC_BW_3db = bandwidth(mag(VF(\342\200\234OUT_AC_3BIT\342\200\235)) 3 \342\200\234low\342\200\235)
  Signals: /OUT_AC_3BIT
Test TRAN_test: multest_devchk/adc_cascode_opamp_sim/sch_Gain_Vio_CMRR_SR, simulator spectre
  Models: /servers/esd_noida/saidarsh/VAEAS2/gpdk090_v4.4/libs.oa22/gpdk090/../../models/spectre/gpdk090.scs[NN], /servers/esd_noida/saidarsh/VAEAS2/gpdk045_v_3_5/gpdk045/../models/spectre/gpdk045.scs[mc]
  Variables: siddq = 1.0; vdd = 2.5; vin_ac = 1.0
  Temperature: 27
  Output average(VT("/Vout2"))
  Signals: /Vout2 as AvgOut
