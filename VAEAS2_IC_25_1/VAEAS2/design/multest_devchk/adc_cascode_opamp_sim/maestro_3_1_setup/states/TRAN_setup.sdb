ADE simulation setup
Run mode: Single Run, Sweeps and Corners
Tests:
  AC_test: multest_devchk/adc_cascode_opamp_sim/sch_dc_ac_2, simulator spectre
    Variables: siddq = 0; vdd = 2.5; vin_ac = 1.0; temperature = 27
    Outputs: "/"; "/uuuu"; /uuuu; /OUT_AC_3BIT; AC_gain_1k
  TRAN_test: multest_devchk/adc_cascode_opamp_sim/sch_Gain_Vio_CMRR_SR, simulator spectre
    Variables: siddq = 1.0; vdd = 2.5; vin_ac = 1.0
    Outputs: AvgOut; average(VT("/Vout2"))
