ADE simulation setup
Test TRAN_test: multest_devchk/adc_cascode_opamp_sim/sch_Gain_Vio_CMRR_SR, simulator spectre
  Models: /servers/esd_noida/anthonys/VADEAssemblerS1/gpdk045_v_3_5/gpdk045/../models/spectre/gpdk045.scs[mc]
  Variables: siddq = 1.0; vdd = 2.5; vin_ac = 1.0
  Temperature: 27
  Analysis dc: (saves the operating point)
  Analysis tran: stop=12u
  Output AvgOut = average(VT("/Vout2"))
  Signals: /Vout2
Test AC_test: multest_devchk/adc_cascode_opamp_sim/sch_dc_ac_2, simulator spectre
  Models: /servers/esd_noida/saidarsh/VAEAS2/gpdk045_v_3_5/models/spectre/gpdk045.scs[mc]
  Variables: temperature = 27; siddq = 0; vdd = 2.5; vin_ac = 1.25
  Temperature: 27
  Analysis ac: start=1 stop=10G dec=20
  Analysis dc: (saves the operating point)
  Output AC_gain_1k = value(mag(VF("/OUT_AC_3BIT")) 1000)
  Output AC_BW_3dB = bandwidth(mag(VF("/OUT_AC_3BIT")) 3 "low")
  Signals: /OUT_AC_3BIT
Run mode: Single Run, Sweeps and Corners
Global variables:
  siddq = 0
  vdd = 2.5
  vin_ac = 1.0 (off)
Specs:
  AC_test / AC_gain_1k: target 115, tolerance 1%
  AC_test / AC_BW_3dB: > 36M
Setup values for test AC_test: vin_ac = 0.5 1.0 1.5
Disabled tests: TRAN_test
