ADE simulation setup
Run mode: Single Run, Sweeps and Corners
Tests:
  AC_test: multest_devchk/adc_cascode_opamp_sim/sch_dc_ac_2, simulator spectre
    Variables: siddq = 1.0; vdd = 2.5; vin_ac = 1.0
    Outputs: AC_test; value(mag(VF("/OUT_AC_3BIT")) 1000); bandwidth(mag(VF("/OUT_AC_3BIT")) 3 "low")
