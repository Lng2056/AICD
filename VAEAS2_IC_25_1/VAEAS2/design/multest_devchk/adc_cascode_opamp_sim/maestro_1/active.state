ADE simulation setup
Test AC_test: multest_devchk/adc_cascode_opamp_sim/sch_dc_ac_2, simulator spectre
  Models: /servers/esd_noida/saidarsh/VAEAS2/gpdk045_v_3_5/models/spectre/gpdk045.scs[mc]
  Variables: siddq = 1.0; vdd = 2.5; vin_ac = 1.0
  Temperature: 27
  Analysis dc: (saves the operating point)
  Analysis noise: start=1 stop=1G p=/OUT_AC_3BIT
  Analysis ac: start=1 stop=10G dec=20
  Output value(mag(VF("/OUT_AC_3BIT")) 1000)
  Output bandwidth(mag(VF("/OUT_AC_3BIT")) 3 "low")
  Signals: /OUT_AC_3BIT as AC_test
Run mode: Single Run, Sweeps and Corners
