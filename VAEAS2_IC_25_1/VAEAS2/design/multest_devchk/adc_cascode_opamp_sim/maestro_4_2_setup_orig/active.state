ADE simulation setup
Test TRAN_test: multest_devchk/adc_cascode_opamp_sim/sch_Gain_Vio_CMRR_SR, simulator spectre
  Models: /servers/esd_noida/anthonys/VADEAssemblerS1/gpdk045_v_3_5/gpdk045/../models/spectre/gpdk045.scs[mc]
  Variables: siddq = 1.0; vdd = 2.5; vin_ac = 1.0
  Temperature: 27
  Analysis dc: (saves the operating point)
  Analysis tran: stop=12u
  Output AvgOut = average(VT("/Vout2")) (unticked)
  Signals: /Vout2
Test AC_test: multest_devchk/adc_cascode_opamp_sim/sch_dc_ac_2, simulator spectre
  Models: /servers/esd_noida/saidarsh/VAEAS2/gpdk045_v_3_5/models/spectre/gpdk045.scs[mc]
  Variables: siddq = 0; vdd = 2.5; vin_ac = 1.25
  Temperature: 27
  Analysis ac: start=1 stop=10G dec=20
  Analysis dc: (saves the operating point)
  Output AC_gain_1k = value(mag(VF("/OUT_AC_3BIT")) 1000) (unticked)
  Output AC_BW_3dB = bandwidth(mag(VF("/OUT_AC_3BIT")) 3 "low") (unticked)
  Output Supply_Current = abs(IDC("/V15/PLUS"))
  Signals: /OUT_AC_3BIT, /V15/PLUS (terminal)
Run mode: Single Run, Sweeps and Corners
Global variables:
  siddq = 0
  vdd = 2.3 2.5 2.8
  vin_ac = 1.0
Specs:
  AC_test / AC_gain_1k: target 115, tolerance 1%
  AC_test / AC_BW_3dB: > 36M
  AC_test / Supply_Current: range 125u to 128u
Setup values for test AC_test: vdd = 2.3 2.5 2.8; vin_ac = 0.5 1.0 1.5
Disabled tests: TRAN_test
