ADE simulation setup
Test AC_test: multest_devchk/adc_cascode_opamp_sim/sch_dc_ac_2, simulator spectre
  Models: /servers/esd_noida/anthonys/VADEAssemblerS1/gpdk045_v_3_5/gpdk045/../models/spectre/gpdk045.scs[mc]
  Variables: siddq = 0; vdd = 2.5; vin_ac = 1.25
  Temperature: 27
  Analysis dc: (saves the operating point)
  Analysis ac: start=1 stop=10G dec=20
  Output AC_gain_1k = value(mag(VF("/OUT_AC_3BIT")) 1000)
  Output AC_BW_3dB = bandwidth(mag(VF("/OUT_AC_3BIT")) 3 "low")
  Signals: /OUT_AC_3BIT
Test TRAN_test: multest_devchk/adc_cascode_opamp_sim/sch_Gain_Vio_CMRR_SR, simulator spectre
  Models: /servers/esd_noida/anthonys/VADEAssemblerS1/gpdk045_v_3_5/gpdk045/../models/spectre/gpdk045.scs[mc]
  Variables: siddq = 1.0; vdd = 2.5; vin_ac = 1.0
  Temperature: 27
  Analysis tran: stop=12u
  Analysis dc: (saves the operating point)
  Output AvgOut = average(VT("/Vout2"))
  Signals: /Vout2
