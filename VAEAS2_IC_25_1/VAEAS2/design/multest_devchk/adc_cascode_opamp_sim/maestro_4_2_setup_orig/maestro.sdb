ADE simulation setup
Run mode: Single Run, Sweeps and Corners
Tests:
  AC_test: multest_devchk/adc_cascode_opamp_sim/sch_dc_ac_2, simulator spectre
    Variables: siddq = 0; vdd = 2.3 2.5 2.8; vin_ac = 0.5 1.0 1.5
    Outputs: /OUT_AC_3BIT; AC_gain_1k; AC_BW_3dB
  TRAN_test (off): multest_devchk/adc_cascode_opamp_sim/sch_Gain_Vio_CMRR_SR, simulator spectre
    Variables: siddq = 1.0; vdd = 2.5; vin_ac = 1.0
    Outputs: /Vout2; AvgOut
Global variables:
  siddq = 0
  vdd = 2.3 2.5 2.8
  vin_ac = 1.0
Specs:
  AC_test / AC_gain_1k: target 115, tolerance 1%
  AC_test / AC_BW_3dB: > 36M
  AC_test / Supply_Current: range 125u to 128u
