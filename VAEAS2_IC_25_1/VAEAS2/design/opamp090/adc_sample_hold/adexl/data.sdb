ADE simulation setup
Tests:
  ether:adc_sample_hold:1: ether/adc_sample_hold/schematic, simulator spectre
