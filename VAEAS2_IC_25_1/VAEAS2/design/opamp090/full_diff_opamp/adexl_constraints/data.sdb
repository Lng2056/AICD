ADE simulation setup
Run mode: Single Run, Sweeps and Corners
Tests:
  opamp090:full_diff_opamp_AC:1: opamp090/full_diff_opamp_AC/schematic, simulator spectre
Global variables:
  gain = 10
  vcm = 1
  vdd = 2
