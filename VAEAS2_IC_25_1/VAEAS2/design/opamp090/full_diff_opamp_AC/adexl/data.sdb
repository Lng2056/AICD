ADE simulation setup
Run mode: Single Run, Sweeps and Corners
Tests:
  AC_TEST: opamp090/full_diff_opamp_AC/config, simulator spectre
  TRAN_TEST: opamp090/full_diff_opamp_TRAN/config, simulator spectre
Global variables:
  gain = 10
  vcm = 1
  vdd = 2
Device parameters:
  opamp090/full_diff_opamp/schematic/C1B.c = C1A/c@opamp090/full_diff_opamp/schematic
  opamp090/full_diff_opamp/schematic/C1A.c = 30.03f
  opamp090/full_diff_opamp/schematic/M1B.l = M1A/l@opamp090/full_diff_opamp/schematic
  opamp090/full_diff_opamp/schematic/M1B.fw = M1A/fw@opamp090/full_diff_opamp/schematic
  opamp090/full_diff_opamp/schematic/M1B.m = 1
  opamp090/full_diff_opamp/schematic/M1B.w = M1A/w@opamp090/full_diff_opamp/schematic
  opamp090/full_diff_opamp/schematic/M1A.l = 320n
  opamp090/full_diff_opamp/schematic/M1A.fw = 30u
  opamp090/full_diff_opamp/schematic/M1A.m = M1B/m@opamp090/full_diff_opamp/schematic
  opamp090/full_diff_opamp/schematic/M1A.w = 60u
  opamp090/full_diff_opamp/schematic/M7A.l = 3.8u:200n:26.2u
  opamp090/full_diff_opamp/schematic/M7A.fw = 20u
  opamp090/full_diff_opamp/schematic/M7A.fingers = 2 * M7D/fingers@opamp090/full_diff_opamp/schematic
  opamp090/full_diff_opamp/schematic/M7D.l = M7A/l@opamp090/full_diff_opamp/schematic
  opamp090/full_diff_opamp/schematic/M7D.fw = M7A/fw@opamp090/full_diff_opamp/schematic
  opamp090/full_diff_opamp/schematic/M7D.fingers = 1:1:5
  opamp090/full_diff_opamp/schematic/M7C.l = M7A/l@opamp090/full_diff_opamp/schematic
  opamp090/full_diff_opamp/schematic/M7C.fw = M7A/fw@opamp090/full_diff_opamp/schematic
  opamp090/full_diff_opamp/schematic/M7C.fingers = 1 * M7D/fingers@opamp090/full_diff_opamp/schematic
  opamp090/full_diff_opamp/schematic/M7B.l = M7A/l@opamp090/full_diff_opamp/schematic
  opamp090/full_diff_opamp/schematic/M7B.fw = M7A/fw@opamp090/full_diff_opamp/schematic
  opamp090/full_diff_opamp/schematic/M7B.fingers = 2 * M7D/fingers@opamp090/full_diff_opamp/schematic
  opamp090/full_diff_opamp/schematic/M8A.l = 1.28u
  opamp090/full_diff_opamp/schematic/M8A.fw = 7.8u
  opamp090/full_diff_opamp/schematic/M8A.fingers = 1:1:5
  opamp090/full_diff_opamp/schematic/M8A.w = 15.6u
  opamp090/full_diff_opamp/schematic/M8B.l = M8A/l@opamp090/full_diff_opamp/schematic
  opamp090/full_diff_opamp/schematic/M8B.fw = M8A/fw@opamp090/full_diff_opamp/schematic
  opamp090/full_diff_opamp/schematic/M8B.fingers = M8A/fingers@opamp090/full_diff_opamp/schematic
  opamp090/full_diff_opamp/schematic/M8B.w = M8A/w@opamp090/full_diff_opamp/schematic
  opamp090/full_diff_opamp/schematic/M11B.l = M11A/l@opamp090/full_diff_opamp/schematic
  opamp090/full_diff_opamp/schematic/M11B.fw = 6u:200n:30u
  opamp090/full_diff_opamp/schematic/M11B.fingers = 1:1:5
  opamp090/full_diff_opamp/schematic/M11B.w = M11A/w@opamp090/full_diff_opamp/schematic
  opamp090/full_diff_opamp/schematic/M11A.l = 1.2u
  opamp090/full_diff_opamp/schematic/M11A.fw = M11B/fw@opamp090/full_diff_opamp/schematic
  opamp090/full_diff_opamp/schematic/M11A.fingers = M11B/fingers@opamp090/full_diff_opamp/schematic
  opamp090/full_diff_opamp/schematic/M11A.w = 96.8u
  opamp090/full_diff_opamp/schematic/M11C.l = M11B/l@opamp090/full_diff_opamp/schematic
  opamp090/full_diff_opamp/schematic/M11C.fw = M11B/fw@opamp090/full_diff_opamp/schematic
  opamp090/full_diff_opamp/schematic/M11C.fingers = M11B/fingers@opamp090/full_diff_opamp/schematic
  opamp090/full_diff_opamp/schematic/R1A.r = 1.15K
  opamp090/full_diff_opamp/schematic/R1A.segW = 2u
  opamp090/full_diff_opamp/schematic/R1B.r = R1A/r@opamp090/full_diff_opamp/schematic
  opamp090/full_diff_opamp/schematic/R1B.segW = R1A/segW@opamp090/full_diff_opamp/schematic
  opamp090/full_diff_opamp/schematic/M21.l = 280n:20n:1.74u
  opamp090/full_diff_opamp/schematic/M21.fw = 25u
  opamp090/full_diff_opamp/schematic/M21.fingers = 1
  opamp090/full_diff_opamp/schematic/M23.l = M21/l@opamp090/full_diff_opamp/schematic
  opamp090/full_diff_opamp/schematic/M23.fw = M21/fw@opamp090/full_diff_opamp/schematic
  opamp090/full_diff_opamp/schematic/M23.fingers = M21/fingers@opamp090/full_diff_opamp/schematic
  opamp090/full_diff_opamp/schematic/M22.l = M21/l@opamp090/full_diff_opamp/schematic
  opamp090/full_diff_opamp/schematic/M22.fw = M21/fw@opamp090/full_diff_opamp/schematic
  opamp090/full_diff_opamp/schematic/M22.fingers = M21/fingers@opamp090/full_diff_opamp/schematic
  opamp090/full_diff_opamp/schematic/M10A.l = M21/l@opamp090/full_diff_opamp/schematic
  opamp090/full_diff_opamp/schematic/M10A.fw = M21/fw@opamp090/full_diff_opamp/schematic
  opamp090/full_diff_opamp/schematic/M10A.fingers = 4 * M21/fingers@opamp090/full_diff_opamp/schematic
  opamp090/full_diff_opamp/schematic/M10B.l = M21/l@opamp090/full_diff_opamp/schematic
  opamp090/full_diff_opamp/schematic/M10B.fw = M21/fw@opamp090/full_diff_opamp/schematic
  opamp090/full_diff_opamp/schematic/M10B.fingers = 4 * M21/fingers@opamp090/full_diff_opamp/schematic
  opamp090/full_diff_opamp/schematic/M4B.l = M21/l@opamp090/full_diff_opamp/schematic
  opamp090/full_diff_opamp/schematic/M4B.fw = M21/fw@opamp090/full_diff_opamp/schematic
  opamp090/full_diff_opamp/schematic/M4B.fingers = 13 * M21/fingers@opamp090/full_diff_opamp/schematic
  opamp090/full_diff_opamp/schematic/M6B.l = M21/l@opamp090/full_diff_opamp/schematic
  opamp090/full_diff_opamp/schematic/M6B.fw = M21/fw@opamp090/full_diff_opamp/schematic
  opamp090/full_diff_opamp/schematic/M6B.fingers = 16 * M21/fingers@opamp090/full_diff_opamp/schematic
  opamp090/full_diff_opamp/schematic/M6A.l = M21/l@opamp090/full_diff_opamp/schematic
  opamp090/full_diff_opamp/schematic/M6A.fw = M21/fw@opamp090/full_diff_opamp/schematic
  opamp090/full_diff_opamp/schematic/M6A.fingers = 16 * M21/fingers@opamp090/full_diff_opamp/schematic
  opamp090/full_diff_opamp/schematic/M4A.l = M21/l@opamp090/full_diff_opamp/schematic
  opamp090/full_diff_opamp/schematic/M4A.fw = M21/fw@opamp090/full_diff_opamp/schematic
  opamp090/full_diff_opamp/schematic/M4A.fingers = 13 * M21/fingers@opamp090/full_diff_opamp/schematic
  opamp090/full_diff_opamp/schematic/M5A.l = 280n:20n:1.42u
  opamp090/full_diff_opamp/schematic/M5A.fingers = 3:1:17
  opamp090/full_diff_opamp/schematic/M5A.fw = M21/fw@opamp090/full_diff_opamp/schematic
  opamp090/full_diff_opamp/schematic/M5B.l = M5A/l@opamp090/full_diff_opamp/schematic
  opamp090/full_diff_opamp/schematic/M5B.fingers = M5A/fingers@opamp090/full_diff_opamp/schematic
  opamp090/full_diff_opamp/schematic/M5B.fw = M21/fw@opamp090/full_diff_opamp/schematic
  opamp090/full_diff_opamp/schematic/M24.l = 280n:20n:1.42u
  opamp090/full_diff_opamp/schematic/M24.fw = 1.2u:200n:8.4u
  opamp090/full_diff_opamp/schematic/M26.l = 280n:20n:1.74u
  opamp090/full_diff_opamp/schematic/M26.fw = M3A/fw@opamp090/full_diff_opamp/schematic
  opamp090/full_diff_opamp/schematic/M26.fingers = 1 * M28/fingers@opamp090/full_diff_opamp/schematic
  opamp090/full_diff_opamp/schematic/M28.l = M26/l@opamp090/full_diff_opamp/schematic
  opamp090/full_diff_opamp/schematic/M28.fw = M3A/fw@opamp090/full_diff_opamp/schematic
  opamp090/full_diff_opamp/schematic/M28.fingers = 1
  opamp090/full_diff_opamp/schematic/M13B.l = M26/l@opamp090/full_diff_opamp/schematic
  opamp090/full_diff_opamp/schematic/M13B.fw = M3A/fw@opamp090/full_diff_opamp/schematic
  opamp090/full_diff_opamp/schematic/M13B.fingers = 2 * M28/fingers@opamp090/full_diff_opamp/schematic
  opamp090/full_diff_opamp/schematic/M13A.l = M26/l@opamp090/full_diff_opamp/schematic
  opamp090/full_diff_opamp/schematic/M13A.fw = M3A/fw@opamp090/full_diff_opamp/schematic
  opamp090/full_diff_opamp/schematic/M13A.fingers = 2 * M28/fingers@opamp090/full_diff_opamp/schematic
  opamp090/full_diff_opamp/schematic/M2B.l = M26/l@opamp090/full_diff_opamp/schematic
  opamp090/full_diff_opamp/schematic/M2B.fw = M3A/fw@opamp090/full_diff_opamp/schematic
  opamp090/full_diff_opamp/schematic/M2B.fingers = 20 * M28/fingers@opamp090/full_diff_opamp/schematic
  opamp090/full_diff_opamp/schematic/M2A.l = M26/l@opamp090/full_diff_opamp/schematic
  opamp090/full_diff_opamp/schematic/M2A.fw = M3A/fw@opamp090/full_diff_opamp/schematic
  opamp090/full_diff_opamp/schematic/M2A.fingers = 20 * M28/fingers@opamp090/full_diff_opamp/schematic
  opamp090/full_diff_opamp/schematic/M13C.l = M26/l@opamp090/full_diff_opamp/schematic
  opamp090/full_diff_opamp/schematic/M13C.fw = M3A/fw@opamp090/full_diff_opamp/schematic
  opamp090/full_diff_opamp/schematic/M13C.fingers = 2 * M28/fingers@opamp090/full_diff_opamp/schematic
  opamp090/full_diff_opamp/schematic/M25.l = 380n:20n:2u
  opamp090/full_diff_opamp/schematic/M25.fw = M3A/fw@opamp090/full_diff_opamp/schematic
  opamp090/full_diff_opamp/schematic/M25.fingers = 1
  opamp090/full_diff_opamp/schematic/M27.l = M25/l@opamp090/full_diff_opamp/schematic
  opamp090/full_diff_opamp/schematic/M27.fw = M3A/fw@opamp090/full_diff_opamp/schematic
  opamp090/full_diff_opamp/schematic/M27.fingers = M25/fingers@opamp090/full_diff_opamp/schematic
  opamp090/full_diff_opamp/schematic/M3A.l = 380n:20n:2u
  opamp090/full_diff_opamp/schematic/M3A.fingers = 3:1:17
  opamp090/full_diff_opamp/schematic/M3A.fw = 11u
  opamp090/full_diff_opamp/schematic/M3B.l = M3A/l@opamp090/full_diff_opamp/schematic
  opamp090/full_diff_opamp/schematic/M3B.fingers = M3A/fingers@opamp090/full_diff_opamp/schematic
  opamp090/full_diff_opamp/schematic/M3B.fw = M3A/fw@opamp090/full_diff_opamp/schematic
  opamp090/full_diff_opamp/schematic/M30.l = 300n
  opamp090/full_diff_opamp/schematic/M30.fw = M31/fw@opamp090/full_diff_opamp/schematic
  opamp090/full_diff_opamp/schematic/M30.fingers = 1
  opamp090/full_diff_opamp/schematic/M31.l = M30/l@opamp090/full_diff_opamp/schematic
  opamp090/full_diff_opamp/schematic/M31.fw = 5.5u
  opamp090/full_diff_opamp/schematic/M31.fingers = M30/fingers@opamp090/full_diff_opamp/schematic
  opamp090/full_diff_opamp/schematic/C2A.c = 50.021f
  opamp090/full_diff_opamp/schematic/C2A.m = 6
  opamp090/full_diff_opamp/schematic/C2B.c = C2A/c@opamp090/full_diff_opamp/schematic
  opamp090/full_diff_opamp/schematic/C2B.m = C2A/m@opamp090/full_diff_opamp/schematic
  opamp090/full_diff_opamp/schematic/M29.fingers = 1
  opamp090/full_diff_opamp/schematic/M29.fw = 1.3u:200n:2.3u
  opamp090/full_diff_opamp/schematic/M29.l = M25/l@opamp090/full_diff_opamp/schematic
  opamp090/ampp/schematic/M1.l = M21/l@opamp090/full_diff_opamp/schematic
  opamp090/ampp/schematic/M1.fw = M21/fw@opamp090/full_diff_opamp/schematic
  opamp090/ampp/schematic/M2.l = M21/l@opamp090/full_diff_opamp/schematic
  opamp090/ampp/schematic/M2.fw = M21/fw@opamp090/full_diff_opamp/schematic
  opamp090/ampp/schematic/M3.l = M24/l@opamp090/full_diff_opamp/schematic
  opamp090/ampp/schematic/M3.fw = M21/fw@opamp090/full_diff_opamp/schematic
  opamp090/ampp/schematic/M4.l = M24/l@opamp090/full_diff_opamp/schematic
  opamp090/ampp/schematic/M4.fw = M21/fw@opamp090/full_diff_opamp/schematic
  opamp090/ampp/schematic/M5.l = M25/l@opamp090/full_diff_opamp/schematic
  opamp090/ampp/schematic/M5.fw = M26/fw@opamp090/full_diff_opamp/schematic
  opamp090/ampp/schematic/M6.l = M25/l@opamp090/full_diff_opamp/schematic
  opamp090/ampp/schematic/M6.fw = M26/fw@opamp090/full_diff_opamp/schematic
  opamp090/ampp/schematic/M7.l = M26/l@opamp090/full_diff_opamp/schematic
  opamp090/ampp/schematic/M7.fw = M26/fw@opamp090/full_diff_opamp/schematic
  opamp090/ampp/schematic/M8.l = M26/l@opamp090/full_diff_opamp/schematic
  opamp090/ampp/schematic/M8.fw = M26/fw@opamp090/full_diff_opamp/schematic
Corners:
  model folders: gpdk090/models/spectre
  C1: temperature=0 100; gpdk090.scs[FF SS]
Specs:
  AC_TEST / DCGain: max 7.5
  AC_TEST / Current: < 10m
  AC_TEST / InputRandomOffset: < 5m
  AC_TEST / GainBandwidth: > 4M
  TRAN_TEST / SettlingTime: < 10n
  TRAN_TEST / SlewRate: > 200M
