ADE simulation setup
Run mode: Single Run, Sweeps and Corners
Tests:
  opamp090:op:1: opamp090/op/schematic, simulator spectre
Global variables:
  vcm = 1
  vdd = 2
Device parameters:
  opamp090/full_diff_opamp/schematic/M8B.l = M8A/l@opamp090/full_diff_opamp/schematic
  opamp090/full_diff_opamp/schematic/M8B.w = M8A/w@opamp090/full_diff_opamp/schematic
  opamp090/full_diff_opamp/schematic/M8B.fw = M8A/fw@opamp090/full_diff_opamp/schematic
  opamp090/full_diff_opamp/schematic/M8A.l = 1.28u
  opamp090/full_diff_opamp/schematic/M8A.w = 15.6u
  opamp090/full_diff_opamp/schematic/M8A.fw = 7.8u
  opamp090/full_diff_opamp/schematic/M3B.fw = M3A/fw@opamp090/full_diff_opamp/schematic
  opamp090/full_diff_opamp/schematic/M3A.fw = 11u
  opamp090/full_diff_opamp/schematic/M25.fw = M3A/fw@opamp090/full_diff_opamp/schematic
  opamp090/full_diff_opamp/schematic/M27.fw = M3A/fw@opamp090/full_diff_opamp/schematic
  opamp090/full_diff_opamp/schematic/M2A.fw = M3A/fw@opamp090/full_diff_opamp/schematic
  opamp090/full_diff_opamp/schematic/M2B.fw = M3A/fw@opamp090/full_diff_opamp/schematic
  opamp090/full_diff_opamp/schematic/M13C.fw = M3A/fw@opamp090/full_diff_opamp/schematic
  opamp090/full_diff_opamp/schematic/M13A.fw = M3A/fw@opamp090/full_diff_opamp/schematic
  opamp090/full_diff_opamp/schematic/M13B.fw = M3A/fw@opamp090/full_diff_opamp/schematic
  opamp090/full_diff_opamp/schematic/M26.fw = M3A/fw@opamp090/full_diff_opamp/schematic
  opamp090/full_diff_opamp/schematic/M28.fw = M3A/fw@opamp090/full_diff_opamp/schematic
  opamp090/full_diff_opamp/schematic/M7B.fw = M7A/fw@opamp090/full_diff_opamp/schematic
  opamp090/full_diff_opamp/schematic/M7A.fw = 20u
  opamp090/full_diff_opamp/schematic/M7C.fw = M7A/fw@opamp090/full_diff_opamp/schematic
  opamp090/full_diff_opamp/schematic/M7D.fw = M7A/fw@opamp090/full_diff_opamp/schematic
  opamp090/full_diff_opamp/schematic/C1B.c = C1A/c@opamp090/full_diff_opamp/schematic
  opamp090/full_diff_opamp/schematic/C1A.c = 30.03f
  opamp090/full_diff_opamp/schematic/M11B.l = M11A/l@opamp090/full_diff_opamp/schematic
  opamp090/full_diff_opamp/schematic/M11B.w = M11A/w@opamp090/full_diff_opamp/schematic
  opamp090/full_diff_opamp/schematic/M11A.l = 1.2u
  opamp090/full_diff_opamp/schematic/M11A.w = 96.8u
  opamp090/full_diff_opamp/schematic/R1B.r = R1A/r@opamp090/full_diff_opamp/schematic
  opamp090/full_diff_opamp/schematic/R1A.r = 1.15K
  opamp090/full_diff_opamp/schematic/M30.fw = M31/fw@opamp090/full_diff_opamp/schematic
  opamp090/full_diff_opamp/schematic/M31.fw = 5.5u
  opamp090/full_diff_opamp/schematic/M22.fw = M21/fw@opamp090/full_diff_opamp/schematic
  opamp090/full_diff_opamp/schematic/M21.fw = 25u
  opamp090/full_diff_opamp/schematic/M23.fw = M21/fw@opamp090/full_diff_opamp/schematic
  opamp090/full_diff_opamp/schematic/M4A.fw = M21/fw@opamp090/full_diff_opamp/schematic
  opamp090/full_diff_opamp/schematic/M6A.fw = M21/fw@opamp090/full_diff_opamp/schematic
  opamp090/full_diff_opamp/schematic/M6B.fw = M21/fw@opamp090/full_diff_opamp/schematic
  opamp090/full_diff_opamp/schematic/M4B.fw = M21/fw@opamp090/full_diff_opamp/schematic
  opamp090/full_diff_opamp/schematic/M10A.fw = M21/fw@opamp090/full_diff_opamp/schematic
  opamp090/full_diff_opamp/schematic/M10B.fw = M21/fw@opamp090/full_diff_opamp/schematic
  opamp090/full_diff_opamp/schematic/M5A.fw = M21/fw@opamp090/full_diff_opamp/schematic
  opamp090/full_diff_opamp/schematic/M5B.fw = M21/fw@opamp090/full_diff_opamp/schematic
  opamp090/full_diff_opamp/schematic/M1B.l = M1A/l@opamp090/full_diff_opamp/schematic
  opamp090/full_diff_opamp/schematic/M1B.w = M1A/w@opamp090/full_diff_opamp/schematic
  opamp090/full_diff_opamp/schematic/M1B.fw = M1A/fw@opamp090/full_diff_opamp/schematic
  opamp090/full_diff_opamp/schematic/M1A.l = 320n
  opamp090/full_diff_opamp/schematic/M1A.w = 60u
  opamp090/full_diff_opamp/schematic/M1A.fw = 30u
  opamp090/full_diff_opamp/schematic/C2B.c = C2A/c@opamp090/full_diff_opamp/schematic
  opamp090/full_diff_opamp/schematic/C2A.c = 50.021f
Specs:
  opamp090:op:1 / Op_Region: < 1
