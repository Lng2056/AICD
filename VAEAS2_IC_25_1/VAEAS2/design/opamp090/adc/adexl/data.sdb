ADE simulation setup
Tests:
  opamp090:adc:1: opamp090/adc/schematic, simulator spectre
