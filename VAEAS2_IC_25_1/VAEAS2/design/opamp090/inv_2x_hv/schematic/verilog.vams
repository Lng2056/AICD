// Verilog-AMS netlist generated by the AMS netlister, version ICOA5.2.51.500.7.
// Cadence Design Systems, Inc.

`include "disciplines.vams"

module inv_2x_hv ( Y,A );

output   Y;
input   A;

wire (*
integer inh_conn_prop_name = "DVDD";
integer
inh_conn_def_value = "cds_globals.\\VDD! ";
 *)
\VDD! ;
wire (*
integer inh_conn_prop_name = "DVSS";
integer
inh_conn_def_value = "cds_globals.\\VSS! ";
 *)
\VSS! ;

gpdk090_pmos2v #(.ps(6.8u), .m(1 * 1), .as(1.68p), .l(280.0n), .pd(6.8u),
 .ad(1.68p), .w(2.8u)) (*
integer library_binding = "gpdk090";

integer passed_mfactor = "m";
 *)
PM0 ( Y, A, \VDD! , \VDD!  );

gpdk090_nmos2v #(.ps(3.44u), .m(1 * 1), .as(672f), .l(280.0n), .pd(3.44u),
 .ad(672f), .w(1.12u)) (*
integer library_binding = "gpdk090";

integer passed_mfactor = "m";
 *)
NM0 ( Y, A, \VSS! , \VSS!  );

endmodule
