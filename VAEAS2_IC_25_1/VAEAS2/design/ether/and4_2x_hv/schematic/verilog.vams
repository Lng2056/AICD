// Verilog-AMS netlist generated by the AMS netlister, version ICOA5.2.51.500.7.
// Cadence Design Systems, Inc.

`include "disciplines.vams"

module and4_2x_hv ( D,C,Y,B,A );

input   D;
input   C;
output   Y;
input   B;
input   A;

wire (*
integer inh_conn_prop_name = "DVDD";
integer
inh_conn_def_value = "cds_globals.\\VDD! ";
 *)
\VDD! ;
wire (*
integer inh_conn_prop_name = "DVSS";
integer
inh_conn_def_value = "cds_globals.\\VSS! ";
 *)
\VSS! ;

gpdk090_pmos2v #(.ps(4u), .m(1 * 1), .as(840f), .l(280.0n), .pd(4u), .ad(840f),
 .w(1.4u)) (*
integer library_binding = "gpdk090";
integer
passed_mfactor = "m";
 *)
PM3 ( net040, B, \VDD! , \VDD!  );
gpdk090_pmos2v #(.ps(4u), .m(1 * 2), .as(840f), .l(280.0n), .pd(2u), .ad(420f),
 .w(1.4u)) (*
integer library_binding = "gpdk090";
integer
passed_mfactor = "m";
 *)
PM2 ( Y, net040, \VDD! , \VDD!  );
gpdk090_pmos2v #(.ps(4u), .m(1 * 1), .as(840f), .l(280.0n), .pd(4u), .ad(840f),
 .w(1.4u)) (*
integer library_binding = "gpdk090";
integer
passed_mfactor = "m";
 *)
PM4 ( net040, A, \VDD! , \VDD!  );
gpdk090_pmos2v #(.ps(4u), .m(1 * 1), .as(840f), .l(280.0n), .pd(4u), .ad(840f),
 .w(1.4u)) (*
integer library_binding = "gpdk090";
integer
passed_mfactor = "m";
 *)
PM1 ( net040, C, \VDD! , \VDD!  );
gpdk090_pmos2v #(.ps(4u), .m(1 * 1), .as(840f), .l(280.0n), .pd(4u), .ad(840f),
 .w(1.4u)) (*
integer library_binding = "gpdk090";
integer
passed_mfactor = "m";
 *)
PM0 ( net040, D, \VDD! , \VDD!  );

gpdk090_nmos2v #(.ps(3.44u), .m(1 * 1), .as(672f), .l(280.0n), .pd(3.44u),
 .ad(672f), .w(1.12u)) (*
integer library_binding = "gpdk090";

integer passed_mfactor = "m";
 *)
NM2 ( Y, net040, \VSS! , \VSS!  );
gpdk090_nmos2v #(.ps(5.68u), .m(1 * 1), .as(1.344p), .l(280.0n), .pd(5.68u),
 .ad(1.344p), .w(2.24u)) (*
integer library_binding = "gpdk090";

integer passed_mfactor = "m";
 *)
NM0 ( net28, C, net078, \VSS!  );
gpdk090_nmos2v #(.ps(5.68u), .m(1 * 1), .as(1.344p), .l(280.0n), .pd(5.68u),
 .ad(1.344p), .w(2.24u)) (*
integer library_binding = "gpdk090";

integer passed_mfactor = "m";
 *)
NM5 ( net078, D, \VSS! , \VSS!  );
gpdk090_nmos2v #(.ps(5.68u), .m(1 * 1), .as(1.344p), .l(280.0n), .pd(5.68u),
 .ad(1.344p), .w(2.24u)) (*
integer library_binding = "gpdk090";

integer passed_mfactor = "m";
 *)
NM4 ( net040, A, net055, \VSS!  );
gpdk090_nmos2v #(.ps(5.68u), .m(1 * 1), .as(1.344p), .l(280.0n), .pd(5.68u),
 .ad(1.344p), .w(2.24u)) (*
integer library_binding = "gpdk090";

integer passed_mfactor = "m";
 *)
NM1 ( net055, B, net28, \VSS!  );

endmodule
