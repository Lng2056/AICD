// Verilog-AMS netlist generated by the AMS netlister, version ICOA5.2.51.500.7.
// Cadence Design Systems, Inc.

`include "disciplines.vams"

module adc_comparator_array_actr ( out,In1n,In1p,SIDDQ,VDD,VSS,
ibias100,in2n,in2p,ph1,ph2b );

output [7:0]  out;
input   In1n;
input   In1p;
input   SIDDQ;
input
 VDD;
input   VSS;
input   ibias100;
input   in2n;
input   in2p;

input   ph1;
input   ph2b;

gpdk090_resnsppoly #(.w(8.4u), .r(100.029), .l(2.09u)) (*
integer
library_binding = "gpdk090";
 *)
R16 ( In1n, in0m, VDD );
gpdk090_resnsppoly #(.w(8.4u), .r(100.029), .l(2.09u)) (*
integer
library_binding = "gpdk090";
 *)
R17 ( In1p, in0, VDD );
gpdk090_resnsppoly #(.w(8.4u), .r(100.029), .l(2.09u)) (*
integer
library_binding = "gpdk090";
 *)
R18 ( in0m, in1m, VDD );
gpdk090_resnsppoly #(.w(8.4u), .r(100.029), .l(2.09u)) (*
integer
library_binding = "gpdk090";
 *)
R19 ( in0, in1, VDD );
gpdk090_resnsppoly #(.w(8.4u), .r(100.029), .l(2.09u)) (*
integer
library_binding = "gpdk090";
 *)
R20 ( in1m, in2m, VDD );
gpdk090_resnsppoly #(.w(8.4u), .r(100.029), .l(2.09u)) (*
integer
library_binding = "gpdk090";
 *)
R21 ( in1, in2, VDD );
gpdk090_resnsppoly #(.w(8.4u), .r(100.029), .l(2.09u)) (*
integer
library_binding = "gpdk090";
 *)
R22 ( in2m, in3m, VDD );
gpdk090_resnsppoly #(.w(8.4u), .r(100.029), .l(2.09u)) (*
integer
library_binding = "gpdk090";
 *)
R23 ( in2, in3, VDD );
gpdk090_resnsppoly #(.w(8.4u), .r(100.029), .l(2.09u)) (*
integer
library_binding = "gpdk090";
 *)
R24 ( in3m, in4m, VDD );
gpdk090_resnsppoly #(.w(8.4u), .r(100.029), .l(2.09u)) (*
integer
library_binding = "gpdk090";
 *)
R25 ( in3, in4, VDD );
gpdk090_resnsppoly #(.w(8.4u), .r(100.029), .l(2.09u)) (*
integer
library_binding = "gpdk090";
 *)
R26 ( in4m, in5m, VDD );
gpdk090_resnsppoly #(.w(8.4u), .r(100.029), .l(2.09u)) (*
integer
library_binding = "gpdk090";
 *)
R27 ( in4, in5, VDD );
gpdk090_resnsppoly #(.w(8.4u), .r(100.029), .l(2.09u)) (*
integer
library_binding = "gpdk090";
 *)
R28 ( in5m, in6m, VDD );
gpdk090_resnsppoly #(.w(8.4u), .r(100.029), .l(2.09u)) (*
integer
library_binding = "gpdk090";
 *)
R29 ( in5, in6, VDD );
gpdk090_resnsppoly #(.w(8.4u), .r(100.029), .l(2.09u)) (*
integer
library_binding = "gpdk090";
 *)
R30 ( in6m, in2n, VDD );
gpdk090_resnsppoly #(.w(8.4u), .r(100.029), .l(2.09u)) (*
integer
library_binding = "gpdk090";
 *)
R31 ( in6, in2p, VDD );

gpdk090_nmos2v #(.ps(21.2u), .m(1 * 1), .as(6p), .l(1u), .pd(21.2u), .ad(6p),
 .w(10u)) (*
integer library_binding = "gpdk090";
integer
passed_mfactor = "m";
 *)
NM0 ( ibias100, ibias100, VSS, VSS );
gpdk090_nmos2v #(.ps(3.6u), .m(1 * 1), .as(720f), .l(280.0n), .pd(3.6u),
 .ad(720f), .w(1.2u)) (*
integer library_binding = "gpdk090";
integer
passed_mfactor = "m";
 *)
NM1 ( ibias100, SIDDQ, VSS, VSS );

adc_comparator_actr (*
integer library_binding = "ether";
 *)
I8 ( .SIDDQ(
SIDDQ ), .inp( in6 ), .outp( out[6] ), .VDD( VDD ), .ph2b( ph2b ), .inm(
in6m ), .ph1( ph1 ), .Vbias( ibias100 ), .VSS( VSS ) );
adc_comparator_actr (*
integer library_binding = "ether";
 *)
I7 ( .SIDDQ(
SIDDQ ), .inp( in2p ), .outp( out[7] ), .VDD( VDD ), .ph2b( ph2b ), .inm(
in2n ), .ph1( ph1 ), .Vbias( ibias100 ), .VSS( VSS ) );
adc_comparator_actr (*
integer library_binding = "ether";
 *)
I6 ( .SIDDQ(
SIDDQ ), .inp( in3 ), .outp( out[3] ), .VDD( VDD ), .ph2b( ph2b ), .inm(
in3m ), .ph1( ph1 ), .Vbias( ibias100 ), .VSS( VSS ) );
adc_comparator_actr (*
integer library_binding = "ether";
 *)
I5 ( .SIDDQ(
SIDDQ ), .inp( in2 ), .outp( out[2] ), .VDD( VDD ), .ph2b( ph2b ), .inm(
in2m ), .ph1( ph1 ), .Vbias( ibias100 ), .VSS( VSS ) );
adc_comparator_actr (*
integer library_binding = "ether";
 *)
I4 ( .SIDDQ(
SIDDQ ), .inp( in5 ), .outp( out[5] ), .VDD( VDD ), .ph2b( ph2b ), .inm(
in5m ), .ph1( ph1 ), .Vbias( ibias100 ), .VSS( VSS ) );
adc_comparator_actr (*
integer library_binding = "ether";
 *)
I3 ( .SIDDQ(
SIDDQ ), .inp( in4 ), .outp( out[4] ), .VDD( VDD ), .ph2b( ph2b ), .inm(
in4m ), .ph1( ph1 ), .Vbias( ibias100 ), .VSS( VSS ) );
adc_comparator_actr (*
integer library_binding = "ether";
 *)
I2 ( .SIDDQ(
SIDDQ ), .inp( in0 ), .outp( out[0] ), .VDD( VDD ), .ph2b( ph2b ), .inm(
in0m ), .ph1( ph1 ), .Vbias( ibias100 ), .VSS( VSS ) );
adc_comparator_actr (*
integer library_binding = "ether";
 *)
I1 ( .SIDDQ(
SIDDQ ), .inp( in1 ), .outp( out[1] ), .VDD( VDD ), .ph2b( ph2b ), .inm(
in1m ), .ph1( ph1 ), .Vbias( ibias100 ), .VSS( VSS ) );

endmodule
