// Verilog-AMS netlist generated by the AMS netlister, version ICOA5.2.51.500.7.
// Cadence Design Systems, Inc.

`include "disciplines.vams"

module inv_1X ( vss,VDD,in,out );

input   vss;
input   VDD;
input   in;
output   out;

parameter td=0;
parameter tr=0;
parameter tf=0;

gpdk090_pmos2v #(.ps(8.2u), .m(1 * 1), .as(2.1p), .l(280.0n), .pd(8.2u),
 .ad(2.1p), .w(3.5u)) (*
integer library_binding = "gpdk090";
integer
passed_mfactor = "m";
 *)
PM1 ( out, in, VDD, VDD );

gpdk090_nmos2v #(.ps(3.53u), .m(1 * 1), .as(699f), .l(280.0n), .pd(3.53u),
 .ad(699f), .w(1.165u)) (*
integer library_binding = "gpdk090";

integer passed_mfactor = "m";
 *)
NM1 ( out, in, vss, vss );

endmodule
