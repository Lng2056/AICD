// Verilog-AMS netlist generated by the AMS netlister, version ICOA5.2.51.500.7.
// Cadence Design Systems, Inc.

`include "disciplines.vams"

module adc_IREF_ext ( BIAS100A,BIAS100B,BIAS100C,BIAS100D,BIAS100E,
BIAS100F,BIAS100G,BIAS100H,BIAS100V,BIAS100Z,BIAS100fA,BIAS100fB,
BIAS50Y,BIAS50f,I100_ext1,I100_ext2,SIDDQ,VDD,VSS );

output   BIAS100A;
output   BIAS100B;
output   BIAS100C;
output
 BIAS100D;
output   BIAS100E;
output   BIAS100F;
output   BIAS100G;

output   BIAS100H;
output   BIAS100V;
output   BIAS100Z;
output
 BIAS100fA;
output   BIAS100fB;
output   BIAS50Y;
output   BIAS50f;

input   I100_ext1;
input   I100_ext2;
input   SIDDQ;
input   VDD;

input   VSS;

gpdk090_pmos2v #(.ps(41.2u), .m(2 * 2), .as(12p), .l(1u), .pd(20.6u),
.ad(6p), .w(20u)) (*
integer library_binding = "gpdk090";
integer
passed_mfactor = "m";
 *)
PM30 ( BIAS100Z, net97, net66, net66 );
gpdk090_pmos2v #(.ps(30.9u), .m(2 * 4), .as(9p), .l(2.5u), .pd(20.6u),
 .ad(6p), .w(20u)) (*
integer library_binding = "gpdk090";
integer
passed_mfactor = "m";
 *)
PM28 ( net70, net135, VDD, VDD );
gpdk090_pmos2v #(.ps(30.9u), .m(2 * 4), .as(9p), .l(2.5u), .pd(20.6u),
 .ad(6p), .w(20u)) (*
integer library_binding = "gpdk090";
integer
passed_mfactor = "m";
 *)
PM4 ( net34, net135, VDD, VDD );
gpdk090_pmos2v #(.ps(41.2u), .m(2 * 2), .as(12p), .l(1u), .pd(20.6u),
.ad(6p), .w(20u)) (*
integer library_binding = "gpdk090";
integer
passed_mfactor = "m";
 *)
PM3 ( BIAS100fA, net97, net34, net34 );
gpdk090_pmos2v #(.ps(41.2u), .m(2 * 2), .as(12p), .l(1u), .pd(20.6u),
.ad(6p), .w(20u)) (*
integer library_binding = "gpdk090";
integer
passed_mfactor = "m";
 *)
PM1 ( BIAS100fB, net97, net38, net38 );
gpdk090_pmos2v #(.ps(30.9u), .m(2 * 4), .as(9p), .l(2.5u), .pd(20.6u),
 .ad(6p), .w(20u)) (*
integer library_binding = "gpdk090";
integer
passed_mfactor = "m";
 *)
PM0 ( net38, net135, VDD, VDD );
gpdk090_pmos2v #(.ps(41.2u), .m(2 * 2), .as(12p), .l(1u), .pd(20.6u),
.ad(6p), .w(20u)) (*
integer library_binding = "gpdk090";
integer
passed_mfactor = "m";
 *)
PM15 ( BIAS100B, net97, net106, net106 );
gpdk090_pmos2v #(.ps(41.2u), .m(1 * 2), .as(12p), .l(1u), .pd(20.6u),
.ad(6p), .w(20u)) (*
integer library_binding = "gpdk090";
integer
passed_mfactor = "m";
 *)
PM13 ( BIAS50f, net97, net46, net46 );
gpdk090_pmos2v #(.ps(30.9u), .m(1 * 4), .as(9p), .l(2.5u), .pd(20.6u),
 .ad(6p), .w(20u)) (*
integer library_binding = "gpdk090";
integer
passed_mfactor = "m";
 *)
PM12 ( net46, net135, VDD, VDD );
gpdk090_pmos2v #(.ps(30.9u), .m(2 * 4), .as(9p), .l(2.5u), .pd(20.6u),
 .ad(6p), .w(20u)) (*
integer library_binding = "gpdk090";
integer
passed_mfactor = "m";
 *)
PM11 ( net114, net135, VDD, VDD );
gpdk090_pmos2v #(.ps(41.2u), .m(2 * 2), .as(12p), .l(1u), .pd(20.6u),
.ad(6p), .w(20u)) (*
integer library_binding = "gpdk090";
integer
passed_mfactor = "m";
 *)
PM10 ( BIAS100A, net97, net114, net114 );
gpdk090_pmos2v #(.ps(30.9u), .m(2 * 4), .as(9p), .l(2.5u), .pd(20.6u),
 .ad(6p), .w(20u)) (*
integer library_binding = "gpdk090";
integer
passed_mfactor = "m";
 *)
PM18 ( net126, net135, VDD, VDD );
gpdk090_pmos2v #(.ps(41.2u), .m(2 * 2), .as(12p), .l(1u), .pd(20.6u),
.ad(6p), .w(20u)) (*
integer library_binding = "gpdk090";
integer
passed_mfactor = "m";
 *)
PM24 ( BIAS100G, net97, net86, net86 );
gpdk090_pmos2v #(.ps(30.9u), .m(2 * 4), .as(9p), .l(2.5u), .pd(20.6u),
 .ad(6p), .w(20u)) (*
integer library_binding = "gpdk090";
integer
passed_mfactor = "m";
 *)
PM14 ( net106, net135, VDD, VDD );
gpdk090_pmos2v #(.ps(30.9u), .m(2 * 4), .as(9p), .l(2.5u), .pd(20.6u),
 .ad(6p), .w(20u)) (*
integer library_binding = "gpdk090";
integer
passed_mfactor = "m";
 *)
PM25 ( net86, net135, VDD, VDD );
gpdk090_pmos2v #(.ps(41.2u), .m(2 * 2), .as(12p), .l(1u), .pd(20.6u),
.ad(6p), .w(20u)) (*
integer library_binding = "gpdk090";
integer
passed_mfactor = "m";
 *)
PM27 ( BIAS100H, net97, net78, net78 );
gpdk090_pmos2v #(.ps(41.2u), .m(1 * 2), .as(12p), .l(1u), .pd(20.6u),
.ad(6p), .w(20u)) (*
integer library_binding = "gpdk090";
integer
passed_mfactor = "m";
 *)
PM33 ( BIAS50Y, net97, net54, net54 );
gpdk090_pmos2v #(.ps(30.9u), .m(1 * 4), .as(9p), .l(2.5u), .pd(20.6u),
 .ad(6p), .w(20u)) (*
integer library_binding = "gpdk090";
integer
passed_mfactor = "m";
 *)
PM32 ( net54, net135, VDD, VDD );
gpdk090_pmos2v #(.ps(30.9u), .m(2 * 4), .as(9p), .l(2.5u), .pd(20.6u),
 .ad(6p), .w(20u)) (*
integer library_binding = "gpdk090";
integer
passed_mfactor = "m";
 *)
PM31 ( net66, net135, VDD, VDD );
gpdk090_pmos2v #(.ps(41.2u), .m(2 * 2), .as(12p), .l(1u), .pd(20.6u),
.ad(6p), .w(20u)) (*
integer library_binding = "gpdk090";
integer
passed_mfactor = "m";
 *)
PM19 ( BIAS100D, net97, net126, net126 );
gpdk090_pmos2v #(.ps(41.2u), .m(2 * 2), .as(12p), .l(1u), .pd(20.6u),
.ad(6p), .w(20u)) (*
integer library_binding = "gpdk090";
integer
passed_mfactor = "m";
 *)
PM16 ( BIAS100C, net97, net138, net138 );
gpdk090_pmos2v #(.ps(41.2u), .m(2 * 2), .as(12p), .l(1u), .pd(20.6u),
.ad(6p), .w(20u)) (*
integer library_binding = "gpdk090";
integer
passed_mfactor = "m";
 *)
PM20 ( BIAS100E, net97, net142, net142 );
gpdk090_pmos2v #(.ps(30.9u), .m(2 * 4), .as(9p), .l(2.5u), .pd(20.6u),
 .ad(6p), .w(20u)) (*
integer library_binding = "gpdk090";
integer
passed_mfactor = "m";
 *)
PM21 ( net142, net135, VDD, VDD );
gpdk090_pmos2v #(.ps(41.2u), .m(2 * 2), .as(12p), .l(1u), .pd(20.6u),
.ad(6p), .w(20u)) (*
integer library_binding = "gpdk090";
integer
passed_mfactor = "m";
 *)
PM23 ( BIAS100F, net97, net150, net150 );
gpdk090_pmos2v #(.ps(30.9u), .m(2 * 4), .as(9p), .l(2.5u), .pd(20.6u),
 .ad(6p), .w(20u)) (*
integer library_binding = "gpdk090";
integer
passed_mfactor = "m";
 *)
PM26 ( net78, net135, VDD, VDD );
gpdk090_pmos2v #(.ps(30.9u), .m(2 * 4), .as(9p), .l(2.5u), .pd(20.6u),
 .ad(6p), .w(20u)) (*
integer library_binding = "gpdk090";
integer
passed_mfactor = "m";
 *)
PM22 ( net150, net135, VDD, VDD );
gpdk090_pmos2v #(.ps(30.9u), .m(2 * 4), .as(9p), .l(2.5u), .pd(20.6u),
 .ad(6p), .w(20u)) (*
integer library_binding = "gpdk090";
integer
passed_mfactor = "m";
 *)
PM17 ( net138, net135, VDD, VDD );
gpdk090_pmos2v #(.ps(41.2u), .m(2 * 2), .as(12p), .l(1u), .pd(20.6u),
.ad(6p), .w(20u)) (*
integer library_binding = "gpdk090";
integer
passed_mfactor = "m";
 *)
PM29 ( BIAS100V, net97, net70, net70 );

adc_IREF_bias (*
integer library_binding = "ether";
 *)
ADC_IREF_BIAS
 ( .pbias( net135 ), .SIDDQ( SIDDQ ), .VDD( VDD ), .Iin1( I100_ext1 ),
.pbias_cas( net97 ), .Iin2( I100_ext2 ), .VSS( VSS ) );

endmodule
