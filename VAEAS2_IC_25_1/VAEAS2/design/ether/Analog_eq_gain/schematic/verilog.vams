// Verilog-AMS netlist generated by the AMS netlister, version ICOA5.2.51.500.7.
// Cadence Design Systems, Inc.

`include "disciplines.vams"

module Analog_eq_gain ( gnd,Rminus,gain,Rplus,plus,minus );

inout   gnd;
output   Rminus;
input [4:0]  gain;
output   Rplus;

inout   plus;
inout   minus;

gpdk090_resnsppoly #(.w(2u), .r(1.99874K), .l(9.98429u)) (*
integer
library_binding = "gpdk090";
 *)
R8 ( plus, net0164, gnd );
gpdk090_resnsppoly #(.w(2u), .r(999.368), .l(4.985u)) (*
integer
library_binding = "gpdk090";
 *)
R30 ( net0164, net079, gnd );
gpdk090_resnsppoly #(.w(10u), .r(199.874), .l(4.985u)) (*
integer
library_binding = "gpdk090";
 *)
R39 ( net095, net0101, gnd );
gpdk090_resnsppoly #(.w(10u), .r(199.874), .l(4.985u)) (*
integer
library_binding = "gpdk090";
 *)
R1 ( net0164, net0143, gnd );
gpdk090_resnsppoly #(.w(20u), .r(99.9368), .l(4.985u)) (*
integer
library_binding = "gpdk090";
 *)
R66 ( net086, net082, gnd );
gpdk090_resnsppoly #(.w(8u), .r(249.842), .l(4.985u)) (*
integer
library_binding = "gpdk090";
 *)
R48 ( net065, net063, gnd );
gpdk090_resnsppoly #(.w(10u), .r(199.874), .l(4.985u)) (*
integer
library_binding = "gpdk090";
 *)
R21 ( net079, net59, gnd );
gpdk090_resnsppoly #(.w(2u), .r(5.99621K), .l(29.9814u)) (*
integer
library_binding = "gpdk090";
 *)
I21 ( Rplus, Rminus, gnd );
gpdk090_resnsppoly #(.w(20u), .r(99.9368), .l(4.985u)) (*
integer
library_binding = "gpdk090";
 *)
R40 ( net0101, net39, gnd );
gpdk090_resnsppoly #(.w(10u), .r(199.874), .l(4.985u)) (*
integer
library_binding = "gpdk090";
 *)
R31 ( net083, net058, gnd );
gpdk090_resnsppoly #(.w(4u), .r(499.684), .l(4.985u)) (*
integer
library_binding = "gpdk090";
 *)
R55 ( net095, net0104, gnd );
gpdk090_resnsppoly #(.w(2u), .r(999.368), .l(4.985u)) (*
integer
library_binding = "gpdk090";
 *)
R56 ( net083, net0104, gnd );
gpdk090_resnsppoly #(.w(10u), .r(199.874), .l(4.985u)) (*
integer
library_binding = "gpdk090";
 *)
R45 ( net0154, net0118, gnd );
gpdk090_resnsppoly #(.w(10u), .r(199.874), .l(4.985u)) (*
integer
library_binding = "gpdk090";
 *)
R35 ( net097, net0111, gnd );
gpdk090_resnsppoly #(.w(20u), .r(100.015), .l(4.99u)) (*
integer
library_binding = "gpdk090";
 *)
R36 ( net0111, net089, gnd );
gpdk090_resnsppoly #(.w(20u), .r(100.015), .l(4.99u)) (*
integer
library_binding = "gpdk090";
 *)
R37 ( net037, net054, gnd );
gpdk090_resnsppoly #(.w(10u), .r(199.874), .l(4.985u)) (*
integer
library_binding = "gpdk090";
 *)
R38 ( net35, net037, gnd );
gpdk090_resnsppoly #(.w(20u), .r(99.9368), .l(4.985u)) (*
integer
library_binding = "gpdk090";
 *)
R46 ( net0118, net80, gnd );
gpdk090_resnsppoly #(.w(8u), .r(249.842), .l(4.985u)) (*
integer
library_binding = "gpdk090";
 *)
R47 ( net059, net0165, gnd );
gpdk090_resnsppoly #(.w(10u), .r(199.874), .l(4.985u)) (*
integer
library_binding = "gpdk090";
 *)
R68 ( net086, net0104, gnd );
gpdk090_resnsppoly #(.w(20u), .r(99.9368), .l(4.985u)) (*
integer
library_binding = "gpdk090";
 *)
R51 ( net0143, net0142, gnd );
gpdk090_resnsppoly #(.w(40u), .r(49.9684), .l(4.985u)) (*
integer
library_binding = "gpdk090";
 *)
R67 ( net073, net082, gnd );
gpdk090_resnsppoly #(.w(2u), .r(999.368), .l(4.985u)) (*
integer
library_binding = "gpdk090";
 *)
R28 ( net0164, net097, gnd );
gpdk090_resnsppoly #(.w(2u), .r(1.99874K), .l(9.98429u)) (*
integer
library_binding = "gpdk090";
integer elaboration_binding
 = "R33[1:5]";
 *)
R33_1 ( net0164, net063, gnd ),
  R33_2 ( net0164, net063, gnd ),
  R33_3 ( net0164, net063, gnd ),
  R33_4 ( net0164, net063, gnd ),
  R33_5 ( net0164, net063, gnd );
gpdk090_resnsppoly #(.w(2u), .r(1.99874K), .l(9.98429u)) (*
integer
library_binding = "gpdk090";
integer elaboration_binding
 = "R43[1:5]";
 *)
R43_1 ( net059, net0104, gnd ),
  R43_2 ( net059, net0104, gnd ),
  R43_3 ( net059, net0104, gnd ),
  R43_4 ( net059, net0104, gnd ),
  R43_5 ( net059, net0104, gnd );
gpdk090_resnsppoly #(.w(4u), .r(499.684), .l(4.985u)) (*
integer
library_binding = "gpdk090";
 *)
R32 ( net0164, net0154, gnd );
gpdk090_resnsppoly #(.w(2u), .r(999.368), .l(4.985u)) (*
integer
library_binding = "gpdk090";
 *)
R57 ( net35, net0104, gnd );
gpdk090_resnsppoly #(.w(40u), .r(49.9684), .l(4.985u)) (*
integer
library_binding = "gpdk090";
 *)
R52 ( net076, net0142, gnd );
gpdk090_resnsppoly #(.w(2u), .r(1.99874K), .l(9.98429u)) (*
integer
library_binding = "gpdk090";
 *)
R10 ( net0104, minus, gnd );

gpdk090_nmos2v #(.ps(24.53u), .m(1 * 1), .as(6.999p), .l(280.0n), .pd(24.53u),
 .ad(6.999p), .w(11.665u)) (*
integer library_binding = "gpdk090";

integer passed_mfactor = "m";
 *)
NM4 ( net054, gain[4], net089, gnd );
gpdk090_nmos2v #(.ps(24.53u), .m(1 * 1), .as(6.999p), .l(280.0n), .pd(24.53u),
 .ad(6.999p), .w(11.665u)) (*
integer library_binding = "gpdk090";

integer passed_mfactor = "m";
 *)
NM2 ( net39, gain[2], net80, gnd );
gpdk090_nmos2v #(.ps(24.53u), .m(1 * 1), .as(6.999p), .l(280.0n), .pd(24.53u),
 .ad(6.999p), .w(11.665u)) (*
integer library_binding = "gpdk090";

integer passed_mfactor = "m";
 *)
NM3 ( net058, gain[3], net59, gnd );
gpdk090_nmos2v #(.ps(21.2u), .m(1 * 1), .as(6p), .l(500n), .pd(21.2u),
 .ad(6p), .w(10u)) (*
integer library_binding = "gpdk090";
integer
passed_mfactor = "m";
 *)
NM0 ( net073, gain[0], net076, gnd );
gpdk090_nmos2v #(.ps(24.53u), .m(1 * 1), .as(6.999p), .l(280.0n), .pd(24.53u),
 .ad(6.999p), .w(11.665u)) (*
integer library_binding = "gpdk090";

integer passed_mfactor = "m";
 *)
NM1 ( net0165, gain[1], net065, gnd );

endmodule
