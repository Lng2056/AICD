// Verilog-AMS netlist generated by the AMS netlister, version ICOA5.2.51.500.7.
// Cadence Design Systems, Inc.

`include "disciplines.vams"

module nor3_2x_hv ( C,Y,B,A );

input   C;
output   Y;
input   B;
input   A;

wire (*
integer inh_conn_prop_name = "DVDD";
integer
inh_conn_def_value = "cds_globals.\\VDD! ";
 *)
\VDD! ;
wire (*
integer inh_conn_prop_name = "DVSS";
integer
inh_conn_def_value = "cds_globals.\\VSS! ";
 *)
\VSS! ;

gpdk090_pmos2v #(.ps(4.53333u), .m(1 * 3), .as(1.12p), .l(280.0n), .pd(4.53333u),
 .ad(1.12p), .w(2.8u)) (*
integer library_binding = "gpdk090";

integer passed_mfactor = "m";
 *)
PM2 ( net036, C, \VDD! , \VDD!  );
gpdk090_pmos2v #(.ps(4.53333u), .m(1 * 3), .as(1.12p), .l(280.0n), .pd(4.53333u),
 .ad(1.12p), .w(2.8u)) (*
integer library_binding = "gpdk090";

integer passed_mfactor = "m";
 *)
PM1 ( Y, A, net027, \VDD!  );
gpdk090_pmos2v #(.ps(4.53333u), .m(1 * 3), .as(1.12p), .l(280.0n), .pd(4.53333u),
 .ad(1.12p), .w(2.8u)) (*
integer library_binding = "gpdk090";

integer passed_mfactor = "m";
 *)
PM0 ( net027, B, net036, \VDD!  );

gpdk090_nmos2v #(.ps(2.8u), .m(1 * 2), .as(472f), .l(280.0n), .pd(1.6u),
 .ad(292f), .w(560n)) (*
integer library_binding = "gpdk090";
integer
passed_mfactor = "m";
 *)
NM0 ( Y, B, \VSS! , \VSS!  );
gpdk090_nmos2v #(.ps(2.8u), .m(1 * 2), .as(472f), .l(280.0n), .pd(1.6u),
 .ad(292f), .w(560n)) (*
integer library_binding = "gpdk090";
integer
passed_mfactor = "m";
 *)
NM2 ( Y, C, \VSS! , \VSS!  );
gpdk090_nmos2v #(.ps(2.8u), .m(1 * 2), .as(472f), .l(280.0n), .pd(1.6u),
 .ad(292f), .w(560n)) (*
integer library_binding = "gpdk090";
integer
passed_mfactor = "m";
 *)
NM1 ( Y, A, \VSS! , \VSS!  );

endmodule
