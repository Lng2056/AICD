// Verilog-AMS netlist generated by the AMS netlister, version ICOA5.2.51.500.7.
// Cadence Design Systems, Inc.

`include "disciplines.vams"

module analog_eq_cm_res ( gnd,vdd,out );

inout   gnd;
inout   vdd;
output   out;

gpdk090_resnsppoly #(.w(3.4u), .r(249.069), .l(2.105u)) (*
integer
library_binding = "gpdk090";
 *)
R1 ( net270, net0102, gnd );
gpdk090_resnsppoly #(.w(3.4u), .r(249.069), .l(2.105u)) (*
integer
library_binding = "gpdk090";
 *)
R106 ( net184, net071, gnd );
gpdk090_resnsppoly #(.w(3.4u), .r(249.069), .l(2.105u)) (*
integer
library_binding = "gpdk090";
 *)
R105 ( net187, net246, gnd );
gpdk090_resnsppoly #(.w(3.4u), .r(249.069), .l(2.105u)) (*
integer
library_binding = "gpdk090";
 *)
R107 ( net190, net240, gnd );
gpdk090_resnsppoly #(.w(3.4u), .r(249.069), .l(2.105u)) (*
integer
library_binding = "gpdk090";
 *)
R108 ( net187, net192, gnd );
gpdk090_resnsppoly #(.w(3.4u), .r(249.069), .l(2.105u)) (*
integer
library_binding = "gpdk090";
 *)
R109 ( net190, net0142, gnd );
gpdk090_resnsppoly #(.w(3.4u), .r(249.069), .l(2.105u)) (*
integer
library_binding = "gpdk090";
 *)
R112 ( out, net0163, gnd );
gpdk090_resnsppoly #(.w(3.4u), .r(249.069), .l(2.105u)) (*
integer
library_binding = "gpdk090";
 *)
R113 ( net211, net0142, gnd );
gpdk090_resnsppoly #(.w(3.4u), .r(249.069), .l(2.105u)) (*
integer
library_binding = "gpdk090";
 *)
R114 ( out, net192, gnd );
gpdk090_resnsppoly #(.w(3.4u), .r(249.069), .l(2.105u)) (*
integer
library_binding = "gpdk090";
 *)
R115 ( net211, net0163, gnd );
gpdk090_resnsppoly #(.w(3.4u), .r(249.069), .l(2.105u)) (*
integer
library_binding = "gpdk090";
 *)
R116 ( net238, net0175, gnd );
gpdk090_resnsppoly #(.w(3.4u), .r(249.069), .l(2.105u)) (*
integer
library_binding = "gpdk090";
 *)
R117 ( net235, net255, gnd );
gpdk090_resnsppoly #(.w(3.4u), .r(249.069), .l(2.105u)) (*
integer
library_binding = "gpdk090";
 *)
R118 ( net238, net065, gnd );
gpdk090_resnsppoly #(.w(3.4u), .r(249.069), .l(2.105u)) (*
integer
library_binding = "gpdk090";
 *)
R104 ( net184, net240, gnd );
gpdk090_resnsppoly #(.w(3.4u), .r(249.069), .l(2.105u)) (*
integer
library_binding = "gpdk090";
 *)
R119 ( net244, net0175, gnd );
gpdk090_resnsppoly #(.w(3.4u), .r(249.069), .l(2.105u)) (*
integer
library_binding = "gpdk090";
 *)
R120 ( net235, net246, gnd );
gpdk090_resnsppoly #(.w(3.4u), .r(249.069), .l(2.105u)) (*
integer
library_binding = "gpdk090";
 *)
R121 ( net244, net071, gnd );
gpdk090_resnsppoly #(.w(3.4u), .r(249.069), .l(2.105u)) (*
integer
library_binding = "gpdk090";
 *)
R122 ( net259, net065, gnd );
gpdk090_resnsppoly #(.w(3.4u), .r(249.069), .l(2.105u)) (*
integer
library_binding = "gpdk090";
 *)
R123 ( net265, net255, gnd );
gpdk090_resnsppoly #(.w(3.4u), .r(249.069), .l(2.105u)) (*
integer
library_binding = "gpdk090";
 *)
R124 ( net259, net270, gnd );
gpdk090_resnsppoly #(.w(3.4u), .r(249.069), .l(2.105u)) (*
integer
library_binding = "gpdk090";
 *)
R125 ( net262, net0268, gnd );
gpdk090_resnsppoly #(.w(3.4u), .r(249.069), .l(2.105u)) (*
integer
library_binding = "gpdk090";
 *)
R126 ( net265, net264, gnd );
gpdk090_resnsppoly #(.w(3.4u), .r(249.069), .l(2.105u)) (*
integer
library_binding = "gpdk090";
 *)
R127 ( net262, net0102, gnd );
gpdk090_resnsppoly #(.w(3.4u), .r(249.069), .l(2.105u)) (*
integer
library_binding = "gpdk090";
 *)
R0 ( net0268, net0105, gnd );
gpdk090_resnsppoly #(.w(3.4u), .r(249.069), .l(2.105u)) (*
integer
library_binding = "gpdk090";
 *)
R97 ( vdd, net0105, gnd );
gpdk090_resnsppoly #(.w(3.4u), .r(249.069), .l(2.105u)) (*
integer
library_binding = "gpdk090";
 *)
R96 ( gnd, net264, gnd );

endmodule
