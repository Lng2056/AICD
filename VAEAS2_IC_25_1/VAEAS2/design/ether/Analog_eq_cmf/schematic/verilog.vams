// Verilog-AMS netlist generated by the AMS netlister, version ICOA5.2.51.500.7.
// Cadence Design Systems, Inc.

`include "disciplines.vams"

module Analog_eq_cmf ( In_P,In_N,gnd,vdd,OutP2,vbiasp,siddq,OutP1 );

input   In_P;
input   In_N;
input   gnd;
input   vdd;
output
 OutP2;
input   vbiasp;
input   siddq;
output   OutP1;

gpdk090_resnsppoly #(.w(2u), .r(95.9943K), .l(479.977u)) (*
integer
library_binding = "gpdk090";
 *)
R0 ( net029, net037, gnd );

gpdk090_pmos2v #(.ps(10.32u), .m(3 * 5), .as(2.88p), .l(800n), .pd(10.32u),
 .ad(2.88p), .w(8u)) (*
integer library_binding = "gpdk090";
integer
passed_mfactor = "m";
 *)
PM11 ( net79, vbiasp, vdd, vdd );
gpdk090_pmos2v #(.ps(61.2u), .m(4 * 2), .as(18p), .l(1u), .pd(30.6u),
.ad(9p), .w(30u)) (*
integer library_binding = "gpdk090";
integer
passed_mfactor = "m";
 *)
PM16 ( net037, In_P, net79, vdd );
gpdk090_pmos2v #(.ps(61.2u), .m(4 * 1), .as(18p), .l(1u), .pd(61.2u),
.ad(18p), .w(30u)) (*
integer library_binding = "gpdk090";
integer
passed_mfactor = "m";
 *)
PM7 ( OutP2, In_N, net79, vdd );
gpdk090_pmos2v #(.ps(61.2u), .m(4 * 1), .as(18p), .l(1u), .pd(61.2u),
.ad(18p), .w(30u)) (*
integer library_binding = "gpdk090";
integer
passed_mfactor = "m";
 *)
PM9 ( OutP1, In_N, net79, vdd );

gpdk090_nmos2v #(.ps(3.53u), .m(1 * 1), .as(699f), .l(280.0n), .pd(3.53u),
 .ad(699f), .w(1.165u)) (*
integer library_binding = "gpdk090";

integer passed_mfactor = "m";
 *)
NM19 ( net037, siddq, gnd, gnd );
gpdk090_nmos2v #(.ps(81.2u), .m(6 * 1), .as(24p), .l(1u), .pd(81.2u),
.ad(24p), .w(40u)) (*
integer library_binding = "gpdk090";
integer
passed_mfactor = "m";
 *)
NM18 ( net037, net037, gnd, gnd );
gpdk090_nmos2v #(.ps(3.53u), .m(1 * 1), .as(699f), .l(280.0n), .pd(3.53u),
 .ad(699f), .w(1.165u)) (*
integer library_binding = "gpdk090";

integer passed_mfactor = "m";
 *)
NM22 ( net79, siddq, gnd, gnd );
gpdk090_nmos2v #(.ps(81.2u), .m(3 * 1), .as(24p), .l(1u), .pd(81.2u),
.ad(24p), .w(40u)) (*
integer library_binding = "gpdk090";
integer
passed_mfactor = "m";
 *)
NM0 ( OutP2, net029, gnd, gnd );
gpdk090_nmos2v #(.ps(81.2u), .m(3 * 1), .as(24p), .l(1u), .pd(81.2u),
.ad(24p), .w(40u)) (*
integer library_binding = "gpdk090";
integer
passed_mfactor = "m";
 *)
NM1 ( OutP1, net029, gnd, gnd );

gpdk090_nmoscap2v #(.m(2 * 20), .l(5u), .w(8.25u)) (*
integer
library_binding = "gpdk090";
integer passed_mfactor = "m";
 *)
C0 (
gnd, net029, gnd, gnd );

endmodule
