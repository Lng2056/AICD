// Verilog-AMS netlist generated by the AMS netlister, version ICOA5.2.51.500.7.
// Cadence Design Systems, Inc.

`include "disciplines.vams"

module tenbt_rec_bias_voltages ( MR_SQUELCH_DISB,RX10_PRESENT,
ibias_rpoly_100u,gnd,vbias_rpoly,vdd,squelch_high,ibias_rpoly2_100u,
siddq,squelch_sel,squelch_low );

input   MR_SQUELCH_DISB;
input   RX10_PRESENT;
input
 ibias_rpoly_100u;
input   gnd;
output   vbias_rpoly;
input   vdd;

output   squelch_high;
input   ibias_rpoly2_100u;
input   siddq;

input [1:0]  squelch_sel;
output   squelch_low;

gpdk090_resnsppoly #(.w(2u), .r(3.20908K), .l(16.035u)) (*
integer
library_binding = "gpdk090";
 *)
R3 ( vbias_rpoly, net157, gnd );

gpdk090_nmos2v #(.ps(7.2u), .m(1 * 2), .as(1.8p), .l(280.0n), .pd(3.6u),
 .ad(900f), .w(3u)) (*
integer library_binding = "gpdk090";
integer
passed_mfactor = "m";
 *)
NM28 ( net113, vbias_rpoly_cas, net106, gnd );
gpdk090_nmos2v #(.ps(37.2u), .m(1 * 1), .as(10.8p), .l(2u), .pd(37.2u),
 .ad(10.8p), .w(18u)) (*
integer library_binding = "gpdk090";
integer
passed_mfactor = "m";
 *)
NM29 ( net106, vbias_rpoly, gnd, gnd );
gpdk090_nmos2v #(.ps(7.2u), .m(1 * 2), .as(1.8p), .l(280.0n), .pd(3.6u),
 .ad(900f), .w(3u)) (*
integer library_binding = "gpdk090";
integer
passed_mfactor = "m";
 *)
NM27 ( net0116, vbias_rpoly_cas, net94, gnd );
gpdk090_nmos2v #(.ps(37.2u), .m(1 * 1), .as(10.8p), .l(2u), .pd(37.2u),
 .ad(10.8p), .w(18u)) (*
integer library_binding = "gpdk090";
integer
passed_mfactor = "m";
 *)
NM11 ( net94, vbias_rpoly, gnd, gnd );
gpdk090_nmos2v #(.ps(19.2u), .m(1 * 1), .as(5.4p), .l(2u), .pd(19.2u),
 .ad(5.4p), .w(9u)) (*
integer library_binding = "gpdk090";
integer
passed_mfactor = "m";
 *)
NM0 ( net0112, vbias_rpoly_cas, gnd, gnd );
gpdk090_nmos2v #(.ps(7.2u), .m(1 * 1), .as(1.8p), .l(280.0n), .pd(7.2u),
 .ad(1.8p), .w(3u)) (*
integer library_binding = "gpdk090";
integer
passed_mfactor = "m";
 *)
NM1 ( vbias_rpoly_cas, vbias_rpoly_cas,
net0112, gnd );
gpdk090_nmos2v #(.ps(37.2u), .m(1 * 2), .as(10.8p), .l(2u), .pd(18.6u),
 .ad(5.4p), .w(18u)) (*
integer library_binding = "gpdk090";
integer
passed_mfactor = "m";
 *)
NM35 ( net238, net157, gnd, gnd );
gpdk090_nmos2v #(.ps(5.4u), .m(1 * 4), .as(1.35p), .l(280.0n), .pd(3.6u),
 .ad(900f), .w(3u)) (*
integer library_binding = "gpdk090";
integer
passed_mfactor = "m";
 *)
NM36 ( net157, vbias_rpoly_cas, net238, gnd );
gpdk090_nmos2v #(.ps(2.8u), .m(1 * 1), .as(462f), .l(280.0n), .pd(2.8u),
 .ad(462f), .w(510n)) (*
integer library_binding = "gpdk090";
integer
passed_mfactor = "m";
 *)
NM38 ( net157, siddq, gnd, gnd );

gpdk090_pmos2v #(.ps(7.2u), .m(1 * 2), .as(1.8p), .l(280.0n), .pd(3.6u),
 .ad(900f), .w(3u)) (*
integer library_binding = "gpdk090";
integer
passed_mfactor = "m";
 *)
PM4 ( net0116, net0116, net0142, vdd );
gpdk090_pmos2v #(.ps(7.2u), .m(4 * 2), .as(1.8p), .l(280.0n), .pd(3.6u),
 .ad(900f), .w(3u)) (*
integer library_binding = "gpdk090";
integer
passed_mfactor = "m";
 *)
PM7 ( net113, net0116, net77, vdd );
gpdk090_pmos2v #(.ps(3.53u), .m(1 * 1), .as(699f), .l(280.0n), .pd(3.53u),
 .ad(699f), .w(1.165u)) (*
integer library_binding = "gpdk090";

integer passed_mfactor = "m";
 *)
PM1 ( net113, siddq_inv, vdd, vdd );
gpdk090_pmos2v #(.ps(7.2u), .m(4 * 2), .as(1.8p), .l(280.0n), .pd(3.6u),
 .ad(900f), .w(3u)) (*
integer library_binding = "gpdk090";
integer
passed_mfactor = "m";
 *)
PM8 ( sq00p, net0116, net200, vdd );
gpdk090_pmos2v #(.ps(15.9u), .m(2 * 4), .as(4.5p), .l(1u), .pd(10.6u),
 .ad(3p), .w(10u)) (*
integer library_binding = "gpdk090";
integer
passed_mfactor = "m";
 *)
PM2 ( net77, net113, vdd, vdd );
gpdk090_pmos2v #(.ps(15.9u), .m(2 * 4), .as(4.5p), .l(1u), .pd(10.6u),
 .ad(3p), .w(10u)) (*
integer library_binding = "gpdk090";
integer
passed_mfactor = "m";
 *)
PM0 ( net200, net113, vdd, vdd );
gpdk090_pmos2v #(.ps(21.2u), .m(1 * 2), .as(6p), .l(1u), .pd(10.6u), .ad(3p),
 .w(10u)) (*
integer library_binding = "gpdk090";
integer
passed_mfactor = "m";
 *)
PM5 ( net0142, net0116, vdd, vdd );
gpdk090_pmos2v #(.ps(24.53u), .m(1 * 2), .as(6.999p), .l(280.0n), .pd(12.265u),
 .ad(3.4995p), .w(11.665u)) (*
integer library_binding = "gpdk090";

integer passed_mfactor = "m";
 *)
PM3 ( net157, siddq,
ibias_rpoly_100u, vdd );
gpdk090_pmos2v #(.ps(24.53u), .m(1 * 2), .as(6.999p), .l(280.0n), .pd(12.265u),
 .ad(3.4995p), .w(11.665u)) (*
integer library_binding = "gpdk090";

integer passed_mfactor = "m";
 *)
PM12 ( vbias_rpoly_cas, siddq,
ibias_rpoly2_100u, vdd );

gpdk090_nmoscap2v #(.m(1 * 1), .l(20u), .w(41.26u)) (*
integer
library_binding = "gpdk090";
integer passed_mfactor = "m";
 *)
C1 (
gnd, squelch_low, gnd, gnd );
gpdk090_nmoscap2v #(.m(1 * 1), .l(20u), .w(41.26u)) (*
integer
library_binding = "gpdk090";
integer passed_mfactor = "m";
 *)
C3 (
gnd, squelch_high, gnd, gnd );
gpdk090_nmoscap2v #(.m(1 * 1), .l(12.5u), .w(26.395u)) (*
integer
library_binding = "gpdk090";
integer passed_mfactor = "m";
 *)
C0 (
gnd, vbias_rpoly, gnd, gnd );

inv_1X (*
integer library_binding = "ether";
 *)
I12 ( .vss( gnd ), .VDD(
vdd ), .in( siddq ), .out( siddq_inv ) );

tenbt_rec_squelch_4in_mux (*
integer library_binding = "ether";
 *)
I6
 ( .MR_SQUELCH_DISB( MR_SQUELCH_DISB ), .RX10_PRESENT( RX10_PRESENT ),
.gnd( gnd ), .sq_10_high( sq10n ), .sq_10_low( net206 ), .vdd( vdd ),
.sq_11_low( net161 ), .sq_01_high( sq01n ), .sq_off( sq_offn ), .squelch_ref_out(
squelch_low ), .sq_00_low( sq10n ), .squelch_sel( squelch_sel[1:0] ),
.sq_01_low( sq11n ), .sq_00_high( sq00n ), .sq_11_high( sq11n ) );
tenbt_rec_squelch_4in_mux (*
integer library_binding = "ether";
 *)
I7
 ( .MR_SQUELCH_DISB( MR_SQUELCH_DISB ), .RX10_PRESENT( RX10_PRESENT ),
.gnd( gnd ), .sq_10_high( sq10p ), .sq_10_low( net234 ), .vdd( vdd ),
.sq_11_low( net197 ), .sq_01_high( sq01p ), .sq_off( sq_offp ), .squelch_ref_out(
squelch_high ), .sq_00_low( sq10p ), .squelch_sel( squelch_sel[1:0] ),
.sq_01_low( sq11p ), .sq_00_high( sq00p ), .sq_11_high( sq11p ) );

tenbt_rec_squelch_res_ladder (*
integer library_binding = "ether";

 *)
I14 ( .sq00highn( sq00n ), .sq_offn( sq_offn ), .sq01low11highn(
sq11n ), .sq_offp( sq_offp ), .sq11lowp( net197 ), .sq01highn( sq01n ),
.sq00low10highn( sq10n ), .sq10lowp( net234 ), .sq11lown( net161 ), .gnd(
gnd ), .sq00highp( sq00p ), .sq01highp( sq01p ), .sq01low11highp(
sq11p ), .sq10lown( net206 ), .sq00low10highp( sq10p ) );

endmodule
