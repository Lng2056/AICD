// Verilog-AMS netlist generated by the AMS netlister, version ICOA5.2.51.500.7.
// Cadence Design Systems, Inc.

`include "disciplines.vams"

module tenbt_rec ( pos,MR_SQUELCH_DISB,MR_BYPASS10RX_FILTER,
ibias_rext_100u,RX10_PRESENT,ibias_rpoly_100u,NEG_SIG_DET,gnd,
MR_SQUELCH_RANGE,neg,vdd,ibias_rpoly2_100u,siddq,POS_SIG_DET,
SLICER_OUT );

input   pos;
input   MR_SQUELCH_DISB;
input   MR_BYPASS10RX_FILTER;

input   ibias_rext_100u;
input   RX10_PRESENT;
input
 ibias_rpoly_100u;
output   NEG_SIG_DET;
input   gnd;
input [1:0]
 MR_SQUELCH_RANGE;
input   neg;
input   vdd;
input
 ibias_rpoly2_100u;
input   siddq;
output   POS_SIG_DET;
output
 SLICER_OUT;

parameter td=0;
parameter td_edge=4E-09;
parameter tr=0;
parameter tf=0;
parameter td_slice=1.2E-09;

gpdk090_resnsppoly #(.w(2u), .r(12.0003K), .l(60.0029u)) (*
integer
library_binding = "gpdk090";
 *)
R1 ( net086, neg, gnd );
gpdk090_resnsppoly #(.w(2u), .r(12.0003K), .l(60.0029u)) (*
integer
library_binding = "gpdk090";
 *)
R3 ( pos_Int, net083, gnd );
gpdk090_resnsppoly #(.w(2u), .r(12.0003K), .l(60.0029u)) (*
integer
library_binding = "gpdk090";
 *)
R0 ( net083, pos, gnd );
gpdk090_resnsppoly #(.w(2u), .r(12.0003K), .l(60.0029u)) (*
integer
library_binding = "gpdk090";
 *)
R2 ( neg_Int, net086, gnd );

gpdk090_nmoscap2v #(.m(1 * 5), .l(18.2u), .w(18.13u)) (*
integer
library_binding = "gpdk090";
integer passed_mfactor = "m";
 *)
C0 (
gnd, vdd, gnd, gnd );
gpdk090_nmoscap2v #(.m(1 * 4), .l(2.875u), .w(2.87u)) (*
integer
library_binding = "gpdk090";
integer passed_mfactor = "m";
 *)
C4 (
gnd, neg_Int, gnd, gnd );
gpdk090_nmoscap2v #(.m(1 * 4), .l(2.875u), .w(2.87u)) (*
integer
library_binding = "gpdk090";
integer passed_mfactor = "m";
 *)
C2 (
gnd, net083, gnd, gnd );
gpdk090_nmoscap2v #(.m(1 * 4), .l(2.875u), .w(2.87u)) (*
integer
library_binding = "gpdk090";
integer passed_mfactor = "m";
 *)
C3 (
gnd, pos_Int, gnd, gnd );
gpdk090_nmoscap2v #(.m(1 * 4), .l(2.875u), .w(2.87u)) (*
integer
library_binding = "gpdk090";
integer passed_mfactor = "m";
 *)
C1 (
gnd, net086, gnd, gnd );

tenbt_rec_squelch_comparator #(.lxStopList("layout abstract autoAbstract compacted symbolic"))
(*
integer library_binding = "ether";
integer cds_net_set[0:1] = {
"DVSS","DVDD" };
integer DVSS = "gnd";
integer DVDD = "vdd";
 *)
I10
 ( .vbias( vbias_const ), .gnd( gnd ), .vdd( vdd ), .Vbias_Poly(
vbias_res_poly ), .in_neg( net109 ), .siddq( siddq ), .out(
POS_SIG_DET ), .in_pos( net110 ) );
tenbt_rec_squelch_comparator #(.lxStopList("layout abstract autoAbstract compacted symbolic"))
(*
integer library_binding = "ether";
integer cds_net_set[0:1] = {
"DVSS","DVDD" };
integer DVSS = "gnd";
integer DVDD = "vdd";
 *)
I11
 ( .vbias( vbias_const ), .gnd( gnd ), .vdd( vdd ), .Vbias_Poly(
vbias_res_poly ), .in_neg( net120 ), .siddq( siddq ), .out(
NEG_SIG_DET ), .in_pos( net121 ) );

tenbt_rec_4_input_comp #(.lxStopList("layout abstract autoAbstract compacted symbolic"))
(*
integer library_binding = "ether";
 *)
I18 ( .out_neg( net109 ), .out_pos(
net110 ), .in_pos1( pos_Int ), .vbias( vbias_res_poly ), .gnd( gnd ),
.vdd( vdd ), .in_pos2( cmsq_low ), .siddq( siddq ), .in_neg1(
cmsq_high ), .in_neg2( neg_Int ) );
tenbt_rec_4_input_comp #(.lxStopList("layout abstract autoAbstract compacted symbolic"))
(*
integer library_binding = "ether";
 *)
I19 ( .out_neg( net120 ), .out_pos(
net121 ), .in_pos1( neg_Int ), .vbias( vbias_res_poly ), .gnd( gnd ),
.vdd( vdd ), .in_pos2( cmsq_low ), .siddq( siddq ), .in_neg1(
cmsq_high ), .in_neg2( pos_Int ) );

tenbt_rec_slicer #(.lxStopList("layout abstract autoAbstract compacted symbolic"))
(*
integer library_binding = "ether";
integer cds_net_set[0:1] = {
"DVDD","DVSS" };
integer DVDD = "vdd";
integer DVSS = "gnd";
 *)
I12
 ( .INP( pos_filt ), .vss( gnd ), .vdd( vdd ), .Vbias_Poly(
vbias_res_poly ), .INN( neg_filt ), .siddq( siddq ), .vbias_const(
vbias_const ), .OUT( SLICER_OUT ) );

tenbt_rec_input_filter #(.lxStopList("layout abstract autoAbstract compacted symbolic"))
(*
integer library_binding = "ether";
 *)
I20 ( .out_neg( neg_filt ),
.INP( pos ), .out_pos( pos_filt ), .vss( gnd ), .vdd( vdd ), .Vbias_Poly(
vbias_res_poly ), .input_filter_off( MR_BYPASS10RX_FILTER ), .INN( neg ),
.siddq( siddq ) );

tenbt_rec_bias_voltages #(.lxStopList("layout abstract autoAbstract compacted symbolic"))
(*
integer library_binding = "ether";
 *)
I17 ( .MR_SQUELCH_DISB(
MR_SQUELCH_DISB ), .RX10_PRESENT( RX10_PRESENT ), .ibias_rpoly_100u(
ibias_rpoly_100u ), .gnd( gnd ), .vdd( vdd ), .vbias_rpoly(
vbias_res_poly ), .squelch_high( cmsq_high ), .ibias_rpoly2_100u(
ibias_rpoly2_100u ), .siddq( siddq ), .squelch_sel(
MR_SQUELCH_RANGE[1:0] ), .squelch_low( cmsq_low ) );

tenbt_rec_current_bias (*
integer library_binding = "ether";
 *)
I24
 ( .ibias_rext_100u( ibias_rext_100u ), .gnd( gnd ), .vdd( vdd ), .siddq(
siddq ), .vbias_const( vbias_const ) );

endmodule
