// Verilog-AMS netlist generated by the AMS netlister, version ICOA5.2.51.500.7.
// Cadence Design Systems, Inc.

`include "disciplines.vams"

module adc_nandx3 ( VDD,B,OUT,VSS,A );

input   VDD;
input   B;
output   OUT;
input   VSS;
input   A;

gpdk090_nmos2v #(.ps(8.2u), .m(1 * 1), .as(2.1p), .l(280.0n), .pd(8.2u),
 .ad(2.1p), .w(3.5u)) (*
integer library_binding = "gpdk090";
integer
passed_mfactor = "m";
 *)
NM0 ( OUT, A, net6, VSS );
gpdk090_nmos2v #(.ps(8.2u), .m(1 * 1), .as(2.1p), .l(280.0n), .pd(8.2u),
 .ad(2.1p), .w(3.5u)) (*
integer library_binding = "gpdk090";
integer
passed_mfactor = "m";
 *)
NM1 ( net6, B, VSS, VSS );

gpdk090_pmos2v #(.ps(15.2u), .m(1 * 1), .as(4.2p), .l(280.0n), .pd(15.2u),
 .ad(4.2p), .w(7u)) (*
integer library_binding = "gpdk090";
integer
passed_mfactor = "m";
 *)
PM0 ( OUT, A, VDD, VDD );
gpdk090_pmos2v #(.ps(15.2u), .m(1 * 1), .as(4.2p), .l(280.0n), .pd(15.2u),
 .ad(4.2p), .w(7u)) (*
integer library_binding = "gpdk090";
integer
passed_mfactor = "m";
 *)
PM1 ( OUT, B, VDD, VDD );

endmodule
