// Verilog-AMS netlist generated by the AMS netlister, version ICOA5.2.51.500.7.
// Cadence Design Systems, Inc.

`include "disciplines.vams"

module tenbt_rec_sq_cmref_mux ( in0,in1,gnd,vdd,out,sel );

input   in0;
input   in1;
input   gnd;
input   vdd;
output   out;

input   sel;

gpdk090_pmos2v #(.ps(24.53u), .m(1 * 2), .as(6.999p), .l(280.0n), .pd(12.265u),
 .ad(3.4995p), .w(11.665u)) (*
integer library_binding = "gpdk090";

integer passed_mfactor = "m";
 *)
PM0 ( out, \!sel , in1, vdd );
gpdk090_pmos2v #(.ps(24.53u), .m(1 * 2), .as(6.999p), .l(280.0n), .pd(12.265u),
 .ad(3.4995p), .w(11.665u)) (*
integer library_binding = "gpdk090";

integer passed_mfactor = "m";
 *)
PM1 ( out, sel, in0, vdd );

gpdk090_nmos2v #(.ps(12.87u), .m(1 * 1), .as(3.501p), .l(280.0n), .pd(12.87u),
 .ad(3.501p), .w(5.835u)) (*
integer library_binding = "gpdk090";

integer passed_mfactor = "m";
 *)
NM0 ( in0, \!sel , out, gnd );
gpdk090_nmos2v #(.ps(12.87u), .m(1 * 1), .as(3.501p), .l(280.0n), .pd(12.87u),
 .ad(3.501p), .w(5.835u)) (*
integer library_binding = "gpdk090";

integer passed_mfactor = "m";
 *)
NM1 ( in1, sel, out, gnd );

inv_1X (*
integer library_binding = "ether";
 *)
I0 ( .vss( gnd ), .VDD(
vdd ), .in( sel ), .out( \!sel  ) );

endmodule
