// Verilog-AMS netlist generated by the AMS netlister, version ICOA5.2.51.500.7.
// Cadence Design Systems, Inc.

`include "disciplines.vams"

module trans_ld_tenbt_bias_pcascode ( S,D,G,B );

inout   S;
inout   D;
inout   G;
inout   B;

gpdk090_pmos2v #(.ps(22u), .m(1 * 9), .as(6.4p), .l(400n), .pd(22u), .ad(6.4p),
 .w(19.2u)) (*
integer library_binding = "gpdk090";
integer
passed_mfactor = "m";
 *)
PM0 ( S, S, S, B );
gpdk090_pmos2v #(.ps(22u), .m(1 * 9), .as(6.4p), .l(400n), .pd(22u), .ad(6.4p),
 .w(19.2u)) (*
integer library_binding = "gpdk090";
integer
passed_mfactor = "m";
 *)
PM86 ( D, G, net25, B );
gpdk090_pmos2v #(.ps(22u), .m(1 * 9), .as(6.4p), .l(400n), .pd(22u), .ad(6.4p),
 .w(19.2u)) (*
integer library_binding = "gpdk090";
integer
passed_mfactor = "m";
 *)
PM129 ( net25, G, net025, B );
gpdk090_pmos2v #(.ps(22u), .m(1 * 9), .as(6.4p), .l(400n), .pd(22u), .ad(6.4p),
 .w(19.2u)) (*
integer library_binding = "gpdk090";
integer
passed_mfactor = "m";
 *)
PM130 ( net025, G, net29, B );
gpdk090_pmos2v #(.ps(22u), .m(1 * 9), .as(6.4p), .l(400n), .pd(22u), .ad(6.4p),
 .w(19.2u)) (*
integer library_binding = "gpdk090";
integer
passed_mfactor = "m";
 *)
PM131 ( net29, G, S, B );

endmodule
