// Verilog-AMS netlist generated by the AMS netlister, version ICOA5.2.51.500.7.
// Cadence Design Systems, Inc.

`include "disciplines.vams"

module dffnr_2x_hv ( CKN,QN,D,RN,Q );

input   CKN;
output   QN;
input   D;
input   RN;
output   Q;

dffr_2x_hv (*
integer library_binding = "ether";
 *)
I1 ( .QN( QN ), .D(
D ), .RN( RN ), .CK( net18 ), .Q( Q ) );

inv_1x_hv (*
integer library_binding = "ether";
 *)
I2 ( .Y( net18 ),
.A( CKN ) );

endmodule
