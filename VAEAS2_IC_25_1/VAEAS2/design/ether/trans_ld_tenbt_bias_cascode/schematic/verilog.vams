// Verilog-AMS netlist generated by the AMS netlister, version ICOA5.2.51.500.7.
// Cadence Design Systems, Inc.

`include "disciplines.vams"

module trans_ld_tenbt_bias_cascode ( S,D,G,B );

inout   S;
inout   D;
inout   G;
inout   B;

gpdk090_nmos2v #(.ps(21.2u), .m(1 * 1), .as(6p), .l(1u), .pd(21.2u), .ad(6p),
 .w(10u)) (*
integer library_binding = "gpdk090";
integer
passed_mfactor = "m";
 *)
NM10 ( net54, G, S, B );
gpdk090_nmos2v #(.ps(21.2u), .m(1 * 1), .as(6p), .l(500n), .pd(21.2u),
 .ad(6p), .w(10u)) (*
integer library_binding = "gpdk090";
integer
passed_mfactor = "m";
 *)
NM30 ( net052, G, net58, B );
gpdk090_nmos2v #(.ps(19.6u), .m(2 * 1), .as(5.52p), .l(500n), .pd(19.6u),
 .ad(5.52p), .w(9.2u)) (*
integer library_binding = "gpdk090";

integer passed_mfactor = "m";
 *)
NM0 ( S, S, S, B );
gpdk090_nmos2v #(.ps(21.2u), .m(1 * 1), .as(6p), .l(500n), .pd(21.2u),
 .ad(6p), .w(10u)) (*
integer library_binding = "gpdk090";
integer
passed_mfactor = "m";
 *)
NM5 ( D, G, net052, B );
gpdk090_nmos2v #(.ps(21.2u), .m(1 * 1), .as(6p), .l(1u), .pd(21.2u), .ad(6p),
 .w(10u)) (*
integer library_binding = "gpdk090";
integer
passed_mfactor = "m";
 *)
NM9 ( net58, G, net54, B );

endmodule
