// Verilog-AMS netlist generated by the AMS netlister, version ICOA5.2.51.500.7.
// Cadence Design Systems, Inc.

`include "disciplines.vams"

module Bias_bg_current_source1_2 ( Vref,I_400u_Rext,CASC_AC_IN,
I_100u_Rext,vss,Vkelvin,VDD,siddq,I_100u_Rext_PLL,I_25u_Rext_PLL,Rext,
CASC_AC_OUT,Ibias );

inout   Vref;
output   I_400u_Rext;
input   CASC_AC_IN;
output
 I_100u_Rext;
inout   vss;
inout   Vkelvin;
input   VDD;
inout
 siddq;
output [1:0]  I_100u_Rext_PLL;
output [1:0]  I_25u_Rext_PLL;

inout   Rext;
output   CASC_AC_OUT;
inout   Ibias;

gpdk090_resnsppoly #(.w(2u), .r(4.99981K), .l(24.9943u)) (*
integer
library_binding = "gpdk090";
 *)
R1 ( Pbias, net0445, vss );
gpdk090_resnsppoly #(.w(2u), .r(2.1627K), .l(10.8029u)) (*
integer
library_binding = "gpdk090";
 *)
R2 ( Vkelvin, net91, vss );
gpdk090_resnsppoly #(.w(5u), .r(200.251), .l(2.49u)) (*
integer
library_binding = "gpdk090";
 *)
R0 ( net0435, Rext, vss );
gpdk090_resnsppoly #(.w(2u), .r(50.0051K), .l(250.032u)) (*
integer
library_binding = "gpdk090";
 *)
R4 ( net0541, net0121, vss );

gpdk090_pmos2v #(.ps(81.2u), .m(2 * 2), .as(24p), .l(4u), .pd(40.6u),
.ad(12p), .w(40u)) (*
integer library_binding = "gpdk090";
integer
passed_mfactor = "m";
 *)
PM198 ( VDD, VDD, VDD, VDD );
gpdk090_pmos2v #(.ps(81.2u), .m(2 * 2), .as(24p), .l(500n), .pd(40.6u),
 .ad(12p), .w(40u)) (*
integer library_binding = "gpdk090";
integer
passed_mfactor = "m";
 *)
PM0 ( net0435, Pcasc, net0146, net0146 );
gpdk090_pmos2v #(.ps(81.2u), .m(2 * 2), .as(24p), .l(500n), .pd(40.6u),
 .ad(12p), .w(40u)) (*
integer library_binding = "gpdk090";
integer
passed_mfactor = "m";
 *)
PM1 ( net139, Pcasc, CASC_AC_OUT,
CASC_AC_OUT );
gpdk090_pmos2v #(.ps(81.2u), .m(2 * 2), .as(24p), .l(500n), .pd(40.6u),
 .ad(12p), .w(40u)) (*
integer library_binding = "gpdk090";
integer
passed_mfactor = "m";
 *)
PM5 ( net0213, Pcasc, net0250, net0250 );
gpdk090_pmos2v #(.ps(81.2u), .m(2 * 2), .as(24p), .l(500n), .pd(40.6u),
 .ad(12p), .w(40u)) (*
integer library_binding = "gpdk090";
integer
passed_mfactor = "m";
 *)
PM9 ( net0121, Pcasc, net0238, net0238 );
gpdk090_pmos2v #(.ps(81.2u), .m(2 * 2), .as(24p), .l(500n), .pd(40.6u),
 .ad(12p), .w(40u)) (*
integer library_binding = "gpdk090";
integer
passed_mfactor = "m";
 *)
PM10 ( VDD, VDD, VDD, VDD );
gpdk090_pmos2v #(.ps(81.2u), .m(2 * 2), .as(24p), .l(500n), .pd(40.6u),
 .ad(12p), .w(40u)) (*
integer library_binding = "gpdk090";
integer
passed_mfactor = "m";
 *)
PM11 ( VDD, VDD, VDD, VDD );
gpdk090_pmos2v #(.ps(81.2u), .m(2 * 2), .as(24p), .l(500n), .pd(40.6u),
 .ad(12p), .w(40u)) (*
integer library_binding = "gpdk090";
integer
passed_mfactor = "m";
 *)
PM41 ( I_100u_Rext, Pcasc, net0294, net0294 );
gpdk090_pmos2v #(.ps(81.2u), .m(8 * 2), .as(24p), .l(500n), .pd(40.6u),
 .ad(12p), .w(40u)) (*
integer library_binding = "gpdk090";
integer
passed_mfactor = "m";
 *)
PM13 ( I_400u_Rext, Pcasc, net0298, net0298 );
gpdk090_pmos2v #(.ps(81.2u), .m(2 * 2), .as(24p), .l(4u), .pd(40.6u),
.ad(12p), .w(40u)) (*
integer library_binding = "gpdk090";
integer
passed_mfactor = "m";
 *)
PM35 ( VDD, VDD, VDD, VDD );
gpdk090_pmos2v #(.ps(81.2u), .m(2 * 2), .as(24p), .l(4u), .pd(40.6u),
.ad(12p), .w(40u)) (*
integer library_binding = "gpdk090";
integer
passed_mfactor = "m";
 *)
PM36 ( net0250, Pbias, VDD, VDD );
gpdk090_pmos2v #(.ps(81.2u), .m(2 * 2), .as(24p), .l(4u), .pd(40.6u),
.ad(12p), .w(40u)) (*
integer library_binding = "gpdk090";
integer
passed_mfactor = "m";
 *)
PM39 ( net0238, Pbias, VDD, VDD );
gpdk090_pmos2v #(.ps(2.8u), .m(1 * 1), .as(476f), .l(280.0n), .pd(2.8u),
 .ad(476f), .w(580n)) (*
integer library_binding = "gpdk090";
integer
passed_mfactor = "m";
 *)
PM43 ( I_100u_Rext_PLL[0], siddq_c, VDD, VDD );
gpdk090_pmos2v #(.ps(81.2u), .m(2 * 2), .as(24p), .l(4u), .pd(40.6u),
.ad(12p), .w(40u)) (*
integer library_binding = "gpdk090";
integer
passed_mfactor = "m";
 *)
PM40 ( net0294, Pbias, VDD, VDD );
gpdk090_pmos2v #(.ps(81.2u), .m(8 * 2), .as(24p), .l(4u), .pd(40.6u),
.ad(12p), .w(40u)) (*
integer library_binding = "gpdk090";
integer
passed_mfactor = "m";
 *)
PM8 ( net0298, Pbias, VDD, VDD );
gpdk090_pmos2v #(.ps(2.8u), .m(1 * 1), .as(460f), .l(280.0n), .pd(2.8u),
 .ad(460f), .w(500n)) (*
integer library_binding = "gpdk090";
integer
passed_mfactor = "m";
 *)
PM46 ( Pbias, siddq_c, VDD, VDD );
gpdk090_pmos2v #(.ps(2.8u), .m(1 * 1), .as(460f), .l(280.0n), .pd(2.8u),
 .ad(460f), .w(500n)) (*
integer library_binding = "gpdk090";
integer
passed_mfactor = "m";
 *)
PM47 ( Pcasc, siddq_c, VDD, VDD );
gpdk090_pmos2v #(.ps(2.8u), .m(1 * 1), .as(476f), .l(280.0n), .pd(2.8u),
 .ad(476f), .w(580n)) (*
integer library_binding = "gpdk090";
integer
passed_mfactor = "m";
 *)
PM42 ( I_100u_Rext_PLL[1], siddq_c, VDD, VDD );
gpdk090_pmos2v #(.ps(81.2u), .m(2 * 2), .as(24p), .l(4u), .pd(40.6u),
.ad(12p), .w(40u)) (*
integer library_binding = "gpdk090";
integer
passed_mfactor = "m";
 *)
PM93 ( CASC_AC_OUT, Pbias, VDD, VDD );
gpdk090_pmos2v #(.ps(2.8u), .m(1 * 1), .as(476f), .l(280.0n), .pd(2.8u),
 .ad(476f), .w(580n)) (*
integer library_binding = "gpdk090";
integer
passed_mfactor = "m";
 *)
PM44 ( I_25u_Rext_PLL[1], siddq_c, VDD, VDD );
gpdk090_pmos2v #(.ps(2.8u), .m(1 * 1), .as(476f), .l(280.0n), .pd(2.8u),
 .ad(476f), .w(580n)) (*
integer library_binding = "gpdk090";
integer
passed_mfactor = "m";
 *)
PM45 ( I_25u_Rext_PLL[0], siddq_c, VDD, VDD );
gpdk090_pmos2v #(.ps(2.8u), .m(1 * 1), .as(460f), .l(280.0n), .pd(2.8u),
 .ad(460f), .w(500n)) (*
integer library_binding = "gpdk090";
integer
passed_mfactor = "m";
 *)
PM6 ( net181, siddq_c, VDD, VDD );
gpdk090_pmos2v #(.ps(21.2u), .m(1 * 1), .as(6p), .l(4u), .pd(21.2u), .ad(6p),
 .w(10u)) (*
integer library_binding = "gpdk090";
integer
passed_mfactor = "m";
 *)
PM2 ( net181, net181, VDD, VDD );
gpdk090_pmos2v #(.ps(21.2u), .m(1 * 1), .as(6p), .l(4u), .pd(21.2u), .ad(6p),
 .w(10u)) (*
integer library_binding = "gpdk090";
integer
passed_mfactor = "m";
 *)
PM4 ( Ib1, net181, VDD, VDD );
gpdk090_pmos2v #(.ps(21.2u), .m(4 * 1), .as(6p), .l(1u), .pd(21.2u), .ad(6p),
 .w(10u)) (*
integer library_binding = "gpdk090";
integer
passed_mfactor = "m";
 *)
PM32 ( Pcasc, CASC_AC_IN, VDD, VDD );
gpdk090_pmos2v #(.ps(81.2u), .m(2 * 2), .as(24p), .l(4u), .pd(40.6u),
.ad(12p), .w(40u)) (*
integer library_binding = "gpdk090";
integer
passed_mfactor = "m";
 *)
PM3 ( net0146, net0445, VDD, VDD );

gpdk090_nmos2v #(.ps(3.2u), .m(1 * 1), .as(600f), .l(280.0n), .pd(3.2u),
 .ad(600f), .w(1u)) (*
integer library_binding = "gpdk090";
integer
passed_mfactor = "m";
 *)
NM5 ( vss, vss, vss, vss );
gpdk090_nmos2v #(.ps(41.2u), .m(1 * 1), .as(12p), .l(6u), .pd(41.2u),
.ad(12p), .w(20u)) (*
integer library_binding = "gpdk090";
integer
passed_mfactor = "m";
 *)
NM60 ( net0229, net0541, vss, vss );
gpdk090_nmos2v #(.ps(41.2u), .m(12 * 1), .as(12p), .l(1u), .pd(41.2u),
 .ad(12p), .w(20u)) (*
integer library_binding = "gpdk090";
integer
passed_mfactor = "m";
 *)
NM58 ( I_100u_Rext_PLL[0], net0213, net0233,
vss );
gpdk090_nmos2v #(.ps(41.2u), .m(3 * 1), .as(12p), .l(1u), .pd(41.2u),
.ad(12p), .w(20u)) (*
integer library_binding = "gpdk090";
integer
passed_mfactor = "m";
 *)
NM61 ( I_25u_Rext_PLL[0], net0213, net0229,
vss );
gpdk090_nmos2v #(.ps(3.2u), .m(1 * 1), .as(600f), .l(280.0n), .pd(3.2u),
 .ad(600f), .w(1u)) (*
integer library_binding = "gpdk090";
integer
passed_mfactor = "m";
 *)
NM39 ( vss, vss, vss, vss );
gpdk090_nmos2v #(.ps(3.2u), .m(1 * 1), .as(600f), .l(280.0n), .pd(3.2u),
 .ad(600f), .w(1u)) (*
integer library_binding = "gpdk090";
integer
passed_mfactor = "m";
 *)
NM40 ( net0213, siddq, vss, vss );
gpdk090_nmos2v #(.ps(3.2u), .m(1 * 1), .as(600f), .l(280.0n), .pd(3.2u),
 .ad(600f), .w(1u)) (*
integer library_binding = "gpdk090";
integer
passed_mfactor = "m";
 *)
NM41 ( net0121, siddq, vss, vss );
gpdk090_nmos2v #(.ps(3.2u), .m(1 * 1), .as(600f), .l(280.0n), .pd(3.2u),
 .ad(600f), .w(1u)) (*
integer library_binding = "gpdk090";
integer
passed_mfactor = "m";
 *)
NM42 ( I_100u_Rext, siddq, vss, vss );
gpdk090_nmos2v #(.ps(3.2u), .m(1 * 1), .as(600f), .l(280.0n), .pd(3.2u),
 .ad(600f), .w(1u)) (*
integer library_binding = "gpdk090";
integer
passed_mfactor = "m";
 *)
NM43 ( I_400u_Rext, siddq, vss, vss );
gpdk090_nmos2v #(.ps(11.2u), .m(1 * 2), .as(3p), .l(6u), .pd(5.6u), .ad(1.5p),
 .w(5u)) (*
integer library_binding = "gpdk090";
integer
passed_mfactor = "m";
 *)
NM38 ( Pcasc, Ibias, vss, vss );
gpdk090_nmos2v #(.ps(21.2u), .m(1 * 1), .as(6p), .l(1u), .pd(21.2u), .ad(6p),
 .w(10u)) (*
integer library_binding = "gpdk090";
integer
passed_mfactor = "m";
 *)
NM55 ( net0213, net0213, net0248, vss );
gpdk090_nmos2v #(.ps(41.2u), .m(12 * 1), .as(12p), .l(1u), .pd(41.2u),
 .ad(12p), .w(20u)) (*
integer library_binding = "gpdk090";
integer
passed_mfactor = "m";
 *)
NM57 ( I_100u_Rext_PLL[1], net0213, net0215,
vss );
gpdk090_nmos2v #(.ps(41.2u), .m(12 * 1), .as(12p), .l(1u), .pd(41.2u),
 .ad(12p), .w(20u)) (*
integer library_binding = "gpdk090";
integer
passed_mfactor = "m";
 *)
NM52 ( net0121, net0213, net0214, vss );
gpdk090_nmos2v #(.ps(30.9u), .m(1 * 4), .as(9p), .l(6u), .pd(20.6u), .ad(6p),
 .w(20u)) (*
integer library_binding = "gpdk090";
integer
passed_mfactor = "m";
 *)
NM51 ( net0215, net0541, vss, vss );
gpdk090_nmos2v #(.ps(21.2u), .m(1 * 1), .as(6p), .l(1u), .pd(21.2u), .ad(6p),
 .w(10u)) (*
integer library_binding = "gpdk090";
integer
passed_mfactor = "m";
 *)
NM53 ( net0252, net0213, vss, vss );
gpdk090_nmos2v #(.ps(2.8u), .m(1 * 1), .as(476f), .l(280.0n), .pd(2.8u),
 .ad(476f), .w(580n)) (*
integer library_binding = "gpdk090";
integer
passed_mfactor = "m";
 *)
NM66 ( net0213, siddq, vss, vss );
gpdk090_nmos2v #(.ps(41.2u), .m(3 * 1), .as(12p), .l(1u), .pd(41.2u),
.ad(12p), .w(20u)) (*
integer library_binding = "gpdk090";
integer
passed_mfactor = "m";
 *)
NM62 ( I_25u_Rext_PLL[1], net0213, net0520,
vss );
gpdk090_nmos2v #(.ps(11.2u), .m(1 * 1), .as(3p), .l(1u), .pd(11.2u), .ad(3p),
 .w(5u)) (*
integer library_binding = "gpdk090";
integer
passed_mfactor = "m";
 *)
NM56 ( net139, net139, vss, vss );
gpdk090_nmos2v #(.ps(2.8u), .m(1 * 1), .as(476f), .l(280.0n), .pd(2.8u),
 .ad(476f), .w(580n)) (*
integer library_binding = "gpdk090";
integer
passed_mfactor = "m";
 *)
NM65 ( net0541, siddq, vss, vss );
gpdk090_nmos2v #(.ps(30.9u), .m(1 * 4), .as(9p), .l(6u), .pd(20.6u), .ad(6p),
 .w(20u)) (*
integer library_binding = "gpdk090";
integer
passed_mfactor = "m";
 *)
NM50 ( net0214, net0121, vss, vss );
gpdk090_nmos2v #(.ps(30.9u), .m(1 * 4), .as(9p), .l(6u), .pd(20.6u), .ad(6p),
 .w(20u)) (*
integer library_binding = "gpdk090";
integer
passed_mfactor = "m";
 *)
NM59 ( net0233, net0541, vss, vss );
gpdk090_nmos2v #(.ps(21.2u), .m(1 * 1), .as(6p), .l(1u), .pd(21.2u), .ad(6p),
 .w(10u)) (*
integer library_binding = "gpdk090";
integer
passed_mfactor = "m";
 *)
NM54 ( net0248, net0213, net0252, vss );
gpdk090_nmos2v #(.ps(41.2u), .m(1 * 1), .as(12p), .l(6u), .pd(41.2u),
.ad(12p), .w(20u)) (*
integer library_binding = "gpdk090";
integer
passed_mfactor = "m";
 *)
NM63 ( net0520, net0541, vss, vss );
gpdk090_nmos2v #(.ps(2.8u), .m(1 * 1), .as(476f), .l(280.0n), .pd(2.8u),
 .ad(476f), .w(580n)) (*
integer library_binding = "gpdk090";
integer
passed_mfactor = "m";
 *)
NM67 ( net139, siddq, vss, vss );
gpdk090_nmos2v #(.ps(2.8u), .m(1 * 1), .as(476f), .l(280.0n), .pd(2.8u),
 .ad(476f), .w(580n)) (*
integer library_binding = "gpdk090";
integer
passed_mfactor = "m";
 *)
NM3 ( Ib1, siddq, vss, vss );
gpdk090_nmos2v #(.ps(2.8u), .m(1 * 1), .as(476f), .l(280.0n), .pd(2.8u),
 .ad(476f), .w(580n)) (*
integer library_binding = "gpdk090";
integer
passed_mfactor = "m";
 *)
NM2 ( Ibias, siddq, vss, vss );
gpdk090_nmos2v #(.ps(11.2u), .m(2 * 1), .as(3p), .l(6u), .pd(11.2u), .ad(3p),
 .w(5u)) (*
integer library_binding = "gpdk090";
integer
passed_mfactor = "m";
 *)
NM0 ( Ibias, Ibias, vss, vss );
gpdk090_nmos2v #(.ps(11.2u), .m(2 * 1), .as(3p), .l(6u), .pd(11.2u), .ad(3p),
 .w(5u)) (*
integer library_binding = "gpdk090";
integer
passed_mfactor = "m";
 *)
NM1 ( net181, Ibias, vss, vss );

gpdk090_pmoscap2v #(.m(1 * 10), .l(2.935u), .w(2.755u)) (*
integer
library_binding = "gpdk090";
integer passed_mfactor = "m";
 *)
C2 (
VDD, Pcasc, VDD, VDD );
gpdk090_pmoscap2v #(.m(1 * 10), .l(16.1u), .w(15.1u)) (*
integer
library_binding = "gpdk090";
integer passed_mfactor = "m";
 *)
C1 (
VDD, Pbias, VDD, VDD );

gpdk090_nmoscap2v #(.m(10 * 1), .l(12.865u), .w(12.825u)) (*
integer
library_binding = "gpdk090";
integer passed_mfactor = "m";
 *)
C3 (
vss, net0541, vss, vss );
gpdk090_nmoscap2v #(.m(8 * 1), .l(12.865u), .w(12.825u)) (*
integer
library_binding = "gpdk090";
integer passed_mfactor = "m";
 *)
C0 (
vss, net0435, vss, vss );

inv_1x_hv (*
integer library_binding = "ether";
integer cds_net_set
[0:1] = { "DVSS","DVDD" };
integer DVSS = "vss";
integer DVDD
 = "VDD";
 *)
I19 ( .Y( siddq_c ), .A( siddq ) );

Bias_opamp_cascode_lowgain (*
integer library_binding = "ether";
 *)

I0 ( .inp( net91 ), .vss( vss ), .VDD( VDD ), .siddq( siddq ), .inm(
Vref ), .ibias1( Ib1 ), .out( net0445 ) );

endmodule
