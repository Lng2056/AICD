// Verilog-AMS netlist generated by the AMS netlister, version ICOA5.2.51.500.7.
// Cadence Design Systems, Inc.

`include "disciplines.vams"

module adc_IREF_poly ( BIAS1000Z,BIAS100INT,BIAS100RL,I100_poly1,
I100_poly2,SIDDQ,VDD,VSS );

output   BIAS1000Z;
output   BIAS100INT;
output   BIAS100RL;
input
 I100_poly1;
input   I100_poly2;
input   SIDDQ;
input   VDD;
input
 VSS;

gpdk090_pmos2v #(.ps(30.9u), .m(2 * 4), .as(9p), .l(2.5u), .pd(20.6u),
 .ad(6p), .w(20u)) (*
integer library_binding = "gpdk090";
integer
passed_mfactor = "m";
 *)
PM0 ( net047, PBIAS, VDD, VDD );
gpdk090_pmos2v #(.ps(41.2u), .m(2 * 2), .as(12p), .l(1u), .pd(20.6u),
.ad(6p), .w(20u)) (*
integer library_binding = "gpdk090";
integer
passed_mfactor = "m";
 *)
PM1 ( BIAS100INT, PBIAS_CAS, net047, net047 );
gpdk090_pmos2v #(.ps(30.9u), .m(2 * 4), .as(9p), .l(2.5u), .pd(20.6u),
 .ad(6p), .w(20u)) (*
integer library_binding = "gpdk090";
integer
passed_mfactor = "m";
 *)
PM2 ( net083, PBIAS, VDD, VDD );
gpdk090_pmos2v #(.ps(41.2u), .m(2 * 2), .as(12p), .l(1u), .pd(20.6u),
.ad(6p), .w(20u)) (*
integer library_binding = "gpdk090";
integer
passed_mfactor = "m";
 *)
PM6 ( VDD, PBIAS_CAS, net079, net079 );
gpdk090_pmos2v #(.ps(41.2u), .m(2 * 2), .as(12p), .l(1u), .pd(20.6u),
.ad(6p), .w(20u)) (*
integer library_binding = "gpdk090";
integer
passed_mfactor = "m";
 *)
PM5 ( VDD, PBIAS_CAS, net083, net083 );
gpdk090_pmos2v #(.ps(30.9u), .m(2 * 4), .as(9p), .l(2.5u), .pd(20.6u),
 .ad(6p), .w(20u)) (*
integer library_binding = "gpdk090";
integer
passed_mfactor = "m";
 *)
PM7 ( net079, PBIAS, VDD, VDD );
gpdk090_pmos2v #(.ps(30.9u), .m(2 * 4), .as(9p), .l(2.5u), .pd(20.6u),
 .ad(6p), .w(20u)) (*
integer library_binding = "gpdk090";
integer
passed_mfactor = "m";
 *)
PM8 ( net067, PBIAS, VDD, VDD );
gpdk090_pmos2v #(.ps(30.9u), .m(2 * 4), .as(9p), .l(2.5u), .pd(20.6u),
 .ad(6p), .w(20u)) (*
integer library_binding = "gpdk090";
integer
passed_mfactor = "m";
 *)
PM11 ( net063, PBIAS, VDD, VDD );
gpdk090_pmos2v #(.ps(41.2u), .m(2 * 2), .as(12p), .l(1u), .pd(20.6u),
.ad(6p), .w(20u)) (*
integer library_binding = "gpdk090";
integer
passed_mfactor = "m";
 *)
PM9 ( VDD, PBIAS_CAS, net067, net067 );
gpdk090_pmos2v #(.ps(41.2u), .m(2 * 2), .as(12p), .l(1u), .pd(20.6u),
.ad(6p), .w(20u)) (*
integer library_binding = "gpdk090";
integer
passed_mfactor = "m";
 *)
PM10 ( VDD, PBIAS_CAS, net063, net063 );
gpdk090_pmos2v #(.ps(30.9u), .m(2 * 4), .as(9p), .l(2.5u), .pd(20.6u),
 .ad(6p), .w(20u)) (*
integer library_binding = "gpdk090";
integer
passed_mfactor = "m";
 *)
PM14 ( net051, PBIAS, VDD, VDD );
gpdk090_pmos2v #(.ps(41.2u), .m(2 * 2), .as(12p), .l(1u), .pd(20.6u),
.ad(6p), .w(20u)) (*
integer library_binding = "gpdk090";
integer
passed_mfactor = "m";
 *)
PM15 ( VDD, PBIAS_CAS, net051, net051 );
gpdk090_pmos2v #(.ps(41.2u), .m(2 * 2), .as(12p), .l(1u), .pd(20.6u),
.ad(6p), .w(20u)) (*
integer library_binding = "gpdk090";
integer
passed_mfactor = "m";
 *)
PM16 ( VDD, PBIAS_CAS, net0209, net0209 );
gpdk090_pmos2v #(.ps(30.9u), .m(2 * 4), .as(9p), .l(2.5u), .pd(20.6u),
 .ad(6p), .w(20u)) (*
integer library_binding = "gpdk090";
integer
passed_mfactor = "m";
 *)
PM17 ( net0209, PBIAS, VDD, VDD );
gpdk090_pmos2v #(.ps(30.9u), .m(2 * 4), .as(9p), .l(2.5u), .pd(20.6u),
 .ad(6p), .w(20u)) (*
integer library_binding = "gpdk090";
integer
passed_mfactor = "m";
 *)
PM18 ( net0107, PBIAS, VDD, VDD );
gpdk090_pmos2v #(.ps(41.2u), .m(2 * 2), .as(12p), .l(1u), .pd(20.6u),
.ad(6p), .w(20u)) (*
integer library_binding = "gpdk090";
integer
passed_mfactor = "m";
 *)
PM19 ( VDD, PBIAS_CAS, net0107, net0107 );
gpdk090_pmos2v #(.ps(41.2u), .m(2 * 2), .as(12p), .l(1u), .pd(20.6u),
.ad(6p), .w(20u)) (*
integer library_binding = "gpdk090";
integer
passed_mfactor = "m";
 *)
PM20 ( VDD, PBIAS_CAS, net0103, net0103 );
gpdk090_pmos2v #(.ps(30.9u), .m(2 * 4), .as(9p), .l(2.5u), .pd(20.6u),
 .ad(6p), .w(20u)) (*
integer library_binding = "gpdk090";
integer
passed_mfactor = "m";
 *)
PM21 ( net0103, PBIAS, VDD, VDD );
gpdk090_pmos2v #(.ps(30.9u), .m(2 * 4), .as(9p), .l(2.5u), .pd(20.6u),
 .ad(6p), .w(20u)) (*
integer library_binding = "gpdk090";
integer
passed_mfactor = "m";
 *)
PM4 ( net84, PBIAS, VDD, VDD );
gpdk090_pmos2v #(.ps(41.2u), .m(2 * 2), .as(12p), .l(1u), .pd(20.6u),
.ad(6p), .w(20u)) (*
integer library_binding = "gpdk090";
integer
passed_mfactor = "m";
 *)
PM3 ( BIAS1000Z, PBIAS_CAS, net84, net84 );
gpdk090_pmos2v #(.ps(41.2u), .m(2 * 2), .as(12p), .l(1u), .pd(20.6u),
.ad(6p), .w(20u)) (*
integer library_binding = "gpdk090";
integer
passed_mfactor = "m";
 *)
PM22 ( VDD, PBIAS_CAS, net095, net095 );
gpdk090_pmos2v #(.ps(30.9u), .m(2 * 4), .as(9p), .l(2.5u), .pd(20.6u),
 .ad(6p), .w(20u)) (*
integer library_binding = "gpdk090";
integer
passed_mfactor = "m";
 *)
PM23 ( net095, PBIAS, VDD, VDD );
gpdk090_pmos2v #(.ps(41.2u), .m(2 * 2), .as(12p), .l(1u), .pd(20.6u),
.ad(6p), .w(20u)) (*
integer library_binding = "gpdk090";
integer
passed_mfactor = "m";
 *)
PM13 ( BIAS100RL, PBIAS_CAS, net88, net88 );
gpdk090_pmos2v #(.ps(30.9u), .m(2 * 4), .as(9p), .l(2.5u), .pd(20.6u),
 .ad(6p), .w(20u)) (*
integer library_binding = "gpdk090";
integer
passed_mfactor = "m";
 *)
PM12 ( net88, PBIAS, VDD, VDD );

adc_IREF_bias (*
integer library_binding = "ether";
 *)
ADC_IREF_BIAS
 ( .pbias( PBIAS ), .SIDDQ( SIDDQ ), .VDD( VDD ), .Iin1( I100_poly1 ),
.pbias_cas( PBIAS_CAS ), .Iin2( I100_poly2 ), .VSS( VSS ) );

endmodule
