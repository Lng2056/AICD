// Verilog-AMS netlist generated by the AMS netlister, version ICOA5.2.51.500.7.
// Cadence Design Systems, Inc.

`include "disciplines.vams"

module Analog_eq_pcaps_zero ( zero,gnd,vdd,bot,top );

input [6:0]  zero;
inout   gnd;
inout   vdd;
input   bot;
input
 top;

gpdk090_pmoscap2v #(.m(1 * 1), .l(5.31u), .w(4.98u)) (*
integer
library_binding = "gpdk090";
integer passed_mfactor = "m";
 *)
C8 (
vdd, net127, vdd, vdd );
gpdk090_pmoscap2v #(.m(1 * 1), .l(5.31u), .w(4.98u)) (*
integer
library_binding = "gpdk090";
integer passed_mfactor = "m";
integer
elaboration_binding = "C28[63:0]";
 *)
C28_63 ( vdd, net262, vdd, vdd ),
  C28_62 ( vdd, net262, vdd, vdd ),
  C28_61 ( vdd, net262, vdd, vdd ),
  C28_60 ( vdd, net262, vdd, vdd ),
  C28_59 ( vdd, net262, vdd, vdd ),
  C28_58 ( vdd, net262, vdd, vdd ),
  C28_57 ( vdd, net262, vdd, vdd ),
  C28_56 ( vdd, net262, vdd, vdd ),
  C28_55 ( vdd, net262, vdd, vdd ),
  C28_54 ( vdd, net262, vdd, vdd ),
  C28_53 ( vdd, net262, vdd, vdd ),
  C28_52 ( vdd, net262, vdd, vdd ),
  C28_51 ( vdd, net262, vdd, vdd ),
  C28_50 ( vdd, net262, vdd, vdd ),
  C28_49 ( vdd, net262, vdd, vdd ),
  C28_48 ( vdd, net262, vdd, vdd ),
  C28_47 ( vdd, net262, vdd, vdd ),
  C28_46 ( vdd, net262, vdd, vdd ),
  C28_45 ( vdd, net262, vdd, vdd ),
  C28_44 ( vdd, net262, vdd, vdd ),
  C28_43 ( vdd, net262, vdd, vdd ),
  C28_42 ( vdd, net262, vdd, vdd ),
  C28_41 ( vdd, net262, vdd, vdd ),
  C28_40 ( vdd, net262, vdd, vdd ),
  C28_39 ( vdd, net262, vdd, vdd ),
  C28_38 ( vdd, net262, vdd, vdd ),
  C28_37 ( vdd, net262, vdd, vdd ),
  C28_36 ( vdd, net262, vdd, vdd ),
  C28_35 ( vdd, net262, vdd, vdd ),
  C28_34 ( vdd, net262, vdd, vdd ),
  C28_33 ( vdd, net262, vdd, vdd ),
  C28_32 ( vdd, net262, vdd, vdd ),
  C28_31 ( vdd, net262, vdd, vdd ),
  C28_30 ( vdd, net262, vdd, vdd ),
  C28_29 ( vdd, net262, vdd, vdd ),
  C28_28 ( vdd, net262, vdd, vdd ),
  C28_27 ( vdd, net262, vdd, vdd ),
  C28_26 ( vdd, net262, vdd, vdd ),
  C28_25 ( vdd, net262, vdd, vdd ),
  C28_24 ( vdd, net262, vdd, vdd ),
  C28_23 ( vdd, net262, vdd, vdd ),
  C28_22 ( vdd, net262, vdd, vdd ),
  C28_21 ( vdd, net262, vdd, vdd ),
  C28_20 ( vdd, net262, vdd, vdd ),
  C28_19 ( vdd, net262, vdd, vdd ),
  C28_18 ( vdd, net262, vdd, vdd ),
  C28_17 ( vdd, net262, vdd, vdd ),
  C28_16 ( vdd, net262, vdd, vdd ),
  C28_15 ( vdd, net262, vdd, vdd ),
  C28_14 ( vdd, net262, vdd, vdd ),
  C28_13 ( vdd, net262, vdd, vdd ),
  C28_12 ( vdd, net262, vdd, vdd ),
  C28_11 ( vdd, net262, vdd, vdd ),
  C28_10 ( vdd, net262, vdd, vdd ),
  C28_9 ( vdd, net262, vdd, vdd ),
  C28_8 ( vdd, net262, vdd, vdd ),
  C28_7 ( vdd, net262, vdd, vdd ),
  C28_6 ( vdd, net262, vdd, vdd ),
  C28_5 ( vdd, net262, vdd, vdd ),
  C28_4 ( vdd, net262, vdd, vdd ),
  C28_3 ( vdd, net262, vdd, vdd ),
  C28_2 ( vdd, net262, vdd, vdd ),
  C28_1 ( vdd, net262, vdd, vdd ),
  C28_0 ( vdd, net262, vdd, vdd );
gpdk090_pmoscap2v #(.m(1 * 1), .l(5.31u), .w(4.98u)) (*
integer
library_binding = "gpdk090";
integer passed_mfactor = "m";
integer
elaboration_binding = "C24[3:0]";
 *)
C24_3 ( vdd, net230, vdd, vdd ),
  C24_2 ( vdd, net230, vdd, vdd ),
  C24_1 ( vdd, net230, vdd, vdd ),
  C24_0 ( vdd, net230, vdd, vdd );
gpdk090_pmoscap2v #(.m(1 * 1), .l(5.31u), .w(4.98u)) (*
integer
library_binding = "gpdk090";
integer passed_mfactor = "m";
integer
elaboration_binding = "C25[7:0]";
 *)
C25_7 ( vdd, net234, vdd, vdd ),
  C25_6 ( vdd, net234, vdd, vdd ),
  C25_5 ( vdd, net234, vdd, vdd ),
  C25_4 ( vdd, net234, vdd, vdd ),
  C25_3 ( vdd, net234, vdd, vdd ),
  C25_2 ( vdd, net234, vdd, vdd ),
  C25_1 ( vdd, net234, vdd, vdd ),
  C25_0 ( vdd, net234, vdd, vdd );
gpdk090_pmoscap2v #(.m(1 * 1), .l(5.31u), .w(4.98u)) (*
integer
library_binding = "gpdk090";
integer passed_mfactor = "m";
integer
elaboration_binding = "C26[15:0]";
 *)
C26_15 ( vdd, net246, vdd, vdd ),
  C26_14 ( vdd, net246, vdd, vdd ),
  C26_13 ( vdd, net246, vdd, vdd ),
  C26_12 ( vdd, net246, vdd, vdd ),
  C26_11 ( vdd, net246, vdd, vdd ),
  C26_10 ( vdd, net246, vdd, vdd ),
  C26_9 ( vdd, net246, vdd, vdd ),
  C26_8 ( vdd, net246, vdd, vdd ),
  C26_7 ( vdd, net246, vdd, vdd ),
  C26_6 ( vdd, net246, vdd, vdd ),
  C26_5 ( vdd, net246, vdd, vdd ),
  C26_4 ( vdd, net246, vdd, vdd ),
  C26_3 ( vdd, net246, vdd, vdd ),
  C26_2 ( vdd, net246, vdd, vdd ),
  C26_1 ( vdd, net246, vdd, vdd ),
  C26_0 ( vdd, net246, vdd, vdd );
gpdk090_pmoscap2v #(.m(1 * 1), .l(5.575u), .w(5.225u)) (*
integer
library_binding = "gpdk090";
integer passed_mfactor = "m";
integer
elaboration_binding = "CSPARE[15:0]";
 *)
CSPARE_15 ( vdd, vdd, vdd,
vdd ),
  CSPARE_14 ( vdd, vdd, vdd, vdd ),
  CSPARE_13 ( vdd, vdd, vdd, vdd ),
  CSPARE_12 ( vdd, vdd, vdd, vdd ),
  CSPARE_11 ( vdd, vdd, vdd, vdd ),
  CSPARE_10 ( vdd, vdd, vdd, vdd ),
  CSPARE_9 ( vdd, vdd, vdd, vdd ),
  CSPARE_8 ( vdd, vdd, vdd, vdd ),
  CSPARE_7 ( vdd, vdd, vdd, vdd ),
  CSPARE_6 ( vdd, vdd, vdd, vdd ),
  CSPARE_5 ( vdd, vdd, vdd, vdd ),
  CSPARE_4 ( vdd, vdd, vdd, vdd ),
  CSPARE_3 ( vdd, vdd, vdd, vdd ),
  CSPARE_2 ( vdd, vdd, vdd, vdd ),
  CSPARE_1 ( vdd, vdd, vdd, vdd ),
  CSPARE_0 ( vdd, vdd, vdd, vdd );
gpdk090_pmoscap2v #(.m(1 * 1), .l(5.31u), .w(4.98u)) (*
integer
library_binding = "gpdk090";
integer passed_mfactor = "m";
integer
elaboration_binding = "C16[63:0]";
 *)
C16_63 ( vdd, net167, vdd, vdd ),
  C16_62 ( vdd, net167, vdd, vdd ),
  C16_61 ( vdd, net167, vdd, vdd ),
  C16_60 ( vdd, net167, vdd, vdd ),
  C16_59 ( vdd, net167, vdd, vdd ),
  C16_58 ( vdd, net167, vdd, vdd ),
  C16_57 ( vdd, net167, vdd, vdd ),
  C16_56 ( vdd, net167, vdd, vdd ),
  C16_55 ( vdd, net167, vdd, vdd ),
  C16_54 ( vdd, net167, vdd, vdd ),
  C16_53 ( vdd, net167, vdd, vdd ),
  C16_52 ( vdd, net167, vdd, vdd ),
  C16_51 ( vdd, net167, vdd, vdd ),
  C16_50 ( vdd, net167, vdd, vdd ),
  C16_49 ( vdd, net167, vdd, vdd ),
  C16_48 ( vdd, net167, vdd, vdd ),
  C16_47 ( vdd, net167, vdd, vdd ),
  C16_46 ( vdd, net167, vdd, vdd ),
  C16_45 ( vdd, net167, vdd, vdd ),
  C16_44 ( vdd, net167, vdd, vdd ),
  C16_43 ( vdd, net167, vdd, vdd ),
  C16_42 ( vdd, net167, vdd, vdd ),
  C16_41 ( vdd, net167, vdd, vdd ),
  C16_40 ( vdd, net167, vdd, vdd ),
  C16_39 ( vdd, net167, vdd, vdd ),
  C16_38 ( vdd, net167, vdd, vdd ),
  C16_37 ( vdd, net167, vdd, vdd ),
  C16_36 ( vdd, net167, vdd, vdd ),
  C16_35 ( vdd, net167, vdd, vdd ),
  C16_34 ( vdd, net167, vdd, vdd ),
  C16_33 ( vdd, net167, vdd, vdd ),
  C16_32 ( vdd, net167, vdd, vdd ),
  C16_31 ( vdd, net167, vdd, vdd ),
  C16_30 ( vdd, net167, vdd, vdd ),
  C16_29 ( vdd, net167, vdd, vdd ),
  C16_28 ( vdd, net167, vdd, vdd ),
  C16_27 ( vdd, net167, vdd, vdd ),
  C16_26 ( vdd, net167, vdd, vdd ),
  C16_25 ( vdd, net167, vdd, vdd ),
  C16_24 ( vdd, net167, vdd, vdd ),
  C16_23 ( vdd, net167, vdd, vdd ),
  C16_22 ( vdd, net167, vdd, vdd ),
  C16_21 ( vdd, net167, vdd, vdd ),
  C16_20 ( vdd, net167, vdd, vdd ),
  C16_19 ( vdd, net167, vdd, vdd ),
  C16_18 ( vdd, net167, vdd, vdd ),
  C16_17 ( vdd, net167, vdd, vdd ),
  C16_16 ( vdd, net167, vdd, vdd ),
  C16_15 ( vdd, net167, vdd, vdd ),
  C16_14 ( vdd, net167, vdd, vdd ),
  C16_13 ( vdd, net167, vdd, vdd ),
  C16_12 ( vdd, net167, vdd, vdd ),
  C16_11 ( vdd, net167, vdd, vdd ),
  C16_10 ( vdd, net167, vdd, vdd ),
  C16_9 ( vdd, net167, vdd, vdd ),
  C16_8 ( vdd, net167, vdd, vdd ),
  C16_7 ( vdd, net167, vdd, vdd ),
  C16_6 ( vdd, net167, vdd, vdd ),
  C16_5 ( vdd, net167, vdd, vdd ),
  C16_4 ( vdd, net167, vdd, vdd ),
  C16_3 ( vdd, net167, vdd, vdd ),
  C16_2 ( vdd, net167, vdd, vdd ),
  C16_1 ( vdd, net167, vdd, vdd ),
  C16_0 ( vdd, net167, vdd, vdd );
gpdk090_pmoscap2v #(.m(1 * 1), .l(5.31u), .w(4.98u)) (*
integer
library_binding = "gpdk090";
integer passed_mfactor = "m";
integer
elaboration_binding = "C22[15:0]";
 *)
C22_15 ( vdd, net155, vdd, vdd ),
  C22_14 ( vdd, net155, vdd, vdd ),
  C22_13 ( vdd, net155, vdd, vdd ),
  C22_12 ( vdd, net155, vdd, vdd ),
  C22_11 ( vdd, net155, vdd, vdd ),
  C22_10 ( vdd, net155, vdd, vdd ),
  C22_9 ( vdd, net155, vdd, vdd ),
  C22_8 ( vdd, net155, vdd, vdd ),
  C22_7 ( vdd, net155, vdd, vdd ),
  C22_6 ( vdd, net155, vdd, vdd ),
  C22_5 ( vdd, net155, vdd, vdd ),
  C22_4 ( vdd, net155, vdd, vdd ),
  C22_3 ( vdd, net155, vdd, vdd ),
  C22_2 ( vdd, net155, vdd, vdd ),
  C22_1 ( vdd, net155, vdd, vdd ),
  C22_0 ( vdd, net155, vdd, vdd );
gpdk090_pmoscap2v #(.m(1 * 1), .l(5.31u), .w(4.98u)) (*
integer
library_binding = "gpdk090";
integer passed_mfactor = "m";
integer
elaboration_binding = "C27[31:0]";
 *)
C27_31 ( vdd, net250, vdd, vdd ),
  C27_30 ( vdd, net250, vdd, vdd ),
  C27_29 ( vdd, net250, vdd, vdd ),
  C27_28 ( vdd, net250, vdd, vdd ),
  C27_27 ( vdd, net250, vdd, vdd ),
  C27_26 ( vdd, net250, vdd, vdd ),
  C27_25 ( vdd, net250, vdd, vdd ),
  C27_24 ( vdd, net250, vdd, vdd ),
  C27_23 ( vdd, net250, vdd, vdd ),
  C27_22 ( vdd, net250, vdd, vdd ),
  C27_21 ( vdd, net250, vdd, vdd ),
  C27_20 ( vdd, net250, vdd, vdd ),
  C27_19 ( vdd, net250, vdd, vdd ),
  C27_18 ( vdd, net250, vdd, vdd ),
  C27_17 ( vdd, net250, vdd, vdd ),
  C27_16 ( vdd, net250, vdd, vdd ),
  C27_15 ( vdd, net250, vdd, vdd ),
  C27_14 ( vdd, net250, vdd, vdd ),
  C27_13 ( vdd, net250, vdd, vdd ),
  C27_12 ( vdd, net250, vdd, vdd ),
  C27_11 ( vdd, net250, vdd, vdd ),
  C27_10 ( vdd, net250, vdd, vdd ),
  C27_9 ( vdd, net250, vdd, vdd ),
  C27_8 ( vdd, net250, vdd, vdd ),
  C27_7 ( vdd, net250, vdd, vdd ),
  C27_6 ( vdd, net250, vdd, vdd ),
  C27_5 ( vdd, net250, vdd, vdd ),
  C27_4 ( vdd, net250, vdd, vdd ),
  C27_3 ( vdd, net250, vdd, vdd ),
  C27_2 ( vdd, net250, vdd, vdd ),
  C27_1 ( vdd, net250, vdd, vdd ),
  C27_0 ( vdd, net250, vdd, vdd );
gpdk090_pmoscap2v #(.m(1 * 1), .l(5.31u), .w(4.98u)) (*
integer
library_binding = "gpdk090";
integer passed_mfactor = "m";
integer
elaboration_binding = "C21[7:0]";
 *)
C21_7 ( vdd, net199, vdd, vdd ),
  C21_6 ( vdd, net199, vdd, vdd ),
  C21_5 ( vdd, net199, vdd, vdd ),
  C21_4 ( vdd, net199, vdd, vdd ),
  C21_3 ( vdd, net199, vdd, vdd ),
  C21_2 ( vdd, net199, vdd, vdd ),
  C21_1 ( vdd, net199, vdd, vdd ),
  C21_0 ( vdd, net199, vdd, vdd );
gpdk090_pmoscap2v #(.m(1 * 1), .l(5.31u), .w(4.98u)) (*
integer
library_binding = "gpdk090";
integer passed_mfactor = "m";
 *)
C9 (
vdd, net179, vdd, vdd );
gpdk090_pmoscap2v #(.m(1 * 1), .l(5.31u), .w(4.98u)) (*
integer
library_binding = "gpdk090";
integer passed_mfactor = "m";
integer
elaboration_binding = "C3[1:0]";
 *)
C3_1 ( vdd, net183, vdd, vdd ),
  C3_0 ( vdd, net183, vdd, vdd );
gpdk090_pmoscap2v #(.m(1 * 1), .l(5.31u), .w(4.98u)) (*
integer
library_binding = "gpdk090";
integer passed_mfactor = "m";
integer
elaboration_binding = "C17[1:0]";
 *)
C17_1 ( vdd, net218, vdd, vdd ),
  C17_0 ( vdd, net218, vdd, vdd );
gpdk090_pmoscap2v #(.m(1 * 1), .l(5.31u), .w(4.98u)) (*
integer
library_binding = "gpdk090";
integer passed_mfactor = "m";
integer
elaboration_binding = "C20[3:0]";
 *)
C20_3 ( vdd, net191, vdd, vdd ),
  C20_2 ( vdd, net191, vdd, vdd ),
  C20_1 ( vdd, net191, vdd, vdd ),
  C20_0 ( vdd, net191, vdd, vdd );
gpdk090_pmoscap2v #(.m(1 * 1), .l(5.31u), .w(4.98u)) (*
integer
library_binding = "gpdk090";
integer passed_mfactor = "m";
integer
elaboration_binding = "C23[31:0]";
 *)
C23_31 ( vdd, net159, vdd, vdd ),
  C23_30 ( vdd, net159, vdd, vdd ),
  C23_29 ( vdd, net159, vdd, vdd ),
  C23_28 ( vdd, net159, vdd, vdd ),
  C23_27 ( vdd, net159, vdd, vdd ),
  C23_26 ( vdd, net159, vdd, vdd ),
  C23_25 ( vdd, net159, vdd, vdd ),
  C23_24 ( vdd, net159, vdd, vdd ),
  C23_23 ( vdd, net159, vdd, vdd ),
  C23_22 ( vdd, net159, vdd, vdd ),
  C23_21 ( vdd, net159, vdd, vdd ),
  C23_20 ( vdd, net159, vdd, vdd ),
  C23_19 ( vdd, net159, vdd, vdd ),
  C23_18 ( vdd, net159, vdd, vdd ),
  C23_17 ( vdd, net159, vdd, vdd ),
  C23_16 ( vdd, net159, vdd, vdd ),
  C23_15 ( vdd, net159, vdd, vdd ),
  C23_14 ( vdd, net159, vdd, vdd ),
  C23_13 ( vdd, net159, vdd, vdd ),
  C23_12 ( vdd, net159, vdd, vdd ),
  C23_11 ( vdd, net159, vdd, vdd ),
  C23_10 ( vdd, net159, vdd, vdd ),
  C23_9 ( vdd, net159, vdd, vdd ),
  C23_8 ( vdd, net159, vdd, vdd ),
  C23_7 ( vdd, net159, vdd, vdd ),
  C23_6 ( vdd, net159, vdd, vdd ),
  C23_5 ( vdd, net159, vdd, vdd ),
  C23_4 ( vdd, net159, vdd, vdd ),
  C23_3 ( vdd, net159, vdd, vdd ),
  C23_2 ( vdd, net159, vdd, vdd ),
  C23_1 ( vdd, net159, vdd, vdd ),
  C23_0 ( vdd, net159, vdd, vdd );

gpdk090_pmos2v #(.ps(3.53u), .m(1 * 1), .as(699f), .l(280.0n), .pd(3.53u),
 .ad(699f), .w(1.165u)) (*
integer library_binding = "gpdk090";

integer passed_mfactor = "m";
 *)
NM0 ( net179, zero[0], vdd, vdd );
gpdk090_pmos2v #(.ps(3.53u), .m(1 * 1), .as(699f), .l(280.0n), .pd(3.53u),
 .ad(699f), .w(1.165u)) (*
integer library_binding = "gpdk090";

integer passed_mfactor = "m";
 *)
PM0 ( vdd, zero[0], net127, vdd );
gpdk090_pmos2v #(.ps(3.53u), .m(1 * 1), .as(699f), .l(280.0n), .pd(3.53u),
 .ad(699f), .w(1.165u)) (*
integer library_binding = "gpdk090";

integer passed_mfactor = "m";
 *)
PM1 ( vdd, zero[1], net218, vdd );
gpdk090_pmos2v #(.ps(3.53u), .m(1 * 1), .as(699f), .l(280.0n), .pd(3.53u),
 .ad(699f), .w(1.165u)) (*
integer library_binding = "gpdk090";

integer passed_mfactor = "m";
 *)
PM2 ( net183, zero[1], vdd, vdd );
gpdk090_pmos2v #(.ps(3.53u), .m(1 * 1), .as(699f), .l(280.0n), .pd(3.53u),
 .ad(699f), .w(1.165u)) (*
integer library_binding = "gpdk090";

integer passed_mfactor = "m";
 *)
PM3 ( net191, zero[2], vdd, vdd );
gpdk090_pmos2v #(.ps(3.53u), .m(1 * 1), .as(699f), .l(280.0n), .pd(3.53u),
 .ad(699f), .w(1.165u)) (*
integer library_binding = "gpdk090";

integer passed_mfactor = "m";
 *)
PM4 ( vdd, zero[2], net230, vdd );
gpdk090_pmos2v #(.ps(3.53u), .m(1 * 1), .as(699f), .l(280.0n), .pd(3.53u),
 .ad(699f), .w(1.165u)) (*
integer library_binding = "gpdk090";

integer passed_mfactor = "m";
 *)
PM5 ( vdd, zero[3], net234, vdd );
gpdk090_pmos2v #(.ps(3.53u), .m(1 * 1), .as(699f), .l(280.0n), .pd(3.53u),
 .ad(699f), .w(1.165u)) (*
integer library_binding = "gpdk090";

integer passed_mfactor = "m";
 *)
PM6 ( net199, zero[3], vdd, vdd );
gpdk090_pmos2v #(.ps(3.53u), .m(1 * 1), .as(699f), .l(280.0n), .pd(3.53u),
 .ad(699f), .w(1.165u)) (*
integer library_binding = "gpdk090";

integer passed_mfactor = "m";
 *)
PM7 ( net155, zero[4], vdd, vdd );
gpdk090_pmos2v #(.ps(3.53u), .m(1 * 1), .as(699f), .l(280.0n), .pd(3.53u),
 .ad(699f), .w(1.165u)) (*
integer library_binding = "gpdk090";

integer passed_mfactor = "m";
 *)
PM8 ( vdd, zero[4], net246, vdd );
gpdk090_pmos2v #(.ps(3.53u), .m(1 * 1), .as(699f), .l(280.0n), .pd(3.53u),
 .ad(699f), .w(1.165u)) (*
integer library_binding = "gpdk090";

integer passed_mfactor = "m";
 *)
PM9 ( vdd, zero[5], net250, vdd );
gpdk090_pmos2v #(.ps(3.53u), .m(1 * 1), .as(699f), .l(280.0n), .pd(3.53u),
 .ad(699f), .w(1.165u)) (*
integer library_binding = "gpdk090";

integer passed_mfactor = "m";
 *)
PM10 ( net159, zero[5], vdd, vdd );
gpdk090_pmos2v #(.ps(3.53u), .m(1 * 1), .as(699f), .l(280.0n), .pd(3.53u),
 .ad(699f), .w(1.165u)) (*
integer library_binding = "gpdk090";

integer passed_mfactor = "m";
 *)
PM11 ( net167, zero[6], vdd, vdd );
gpdk090_pmos2v #(.ps(3.53u), .m(1 * 1), .as(699f), .l(280.0n), .pd(3.53u),
 .ad(699f), .w(1.165u)) (*
integer library_binding = "gpdk090";

integer passed_mfactor = "m";
 *)
PM12 ( vdd, zero[6], net262, vdd );

gpdk090_nmos2v #(.ps(31.2u), .m(1 * 1), .as(9p), .l(280.0n), .pd(31.2u),
 .ad(9p), .w(15u)) (*
integer library_binding = "gpdk090";
integer
passed_mfactor = "m";
 *)
NM23 ( bot, zero[4], net246, gnd );
gpdk090_nmos2v #(.ps(31.2u), .m(1 * 1), .as(9p), .l(280.0n), .pd(31.2u),
 .ad(9p), .w(15u)) (*
integer library_binding = "gpdk090";
integer
passed_mfactor = "m";
 *)
NM22 ( net155, zero[4], top, gnd );
gpdk090_nmos2v #(.ps(31.2u), .m(1 * 1), .as(9p), .l(280.0n), .pd(31.2u),
 .ad(9p), .w(15u)) (*
integer library_binding = "gpdk090";
integer
passed_mfactor = "m";
 *)
NM21 ( net159, zero[5], top, gnd );
gpdk090_nmos2v #(.ps(31.2u), .m(1 * 1), .as(9p), .l(280.0n), .pd(31.2u),
 .ad(9p), .w(15u)) (*
integer library_binding = "gpdk090";
integer
passed_mfactor = "m";
 *)
NM20 ( bot, zero[5], net250, gnd );
gpdk090_nmos2v #(.ps(31.2u), .m(1 * 1), .as(9p), .l(280.0n), .pd(31.2u),
 .ad(9p), .w(15u)) (*
integer library_binding = "gpdk090";
integer
passed_mfactor = "m";
 *)
NM19 ( net167, zero[6], top, gnd );
gpdk090_nmos2v #(.ps(31.2u), .m(1 * 1), .as(9p), .l(280.0n), .pd(31.2u),
 .ad(9p), .w(15u)) (*
integer library_binding = "gpdk090";
integer
passed_mfactor = "m";
 *)
NM18 ( bot, zero[6], net262, gnd );
gpdk090_nmos2v #(.ps(31.2u), .m(1 * 1), .as(9p), .l(280.0n), .pd(31.2u),
 .ad(9p), .w(15u)) (*
integer library_binding = "gpdk090";
integer
passed_mfactor = "m";
 *)
NM8 ( bot, zero[0], net127, gnd );
gpdk090_nmos2v #(.ps(31.2u), .m(1 * 1), .as(9p), .l(280.0n), .pd(31.2u),
 .ad(9p), .w(15u)) (*
integer library_binding = "gpdk090";
integer
passed_mfactor = "m";
 *)
NM9 ( net179, zero[0], top, gnd );
gpdk090_nmos2v #(.ps(31.2u), .m(1 * 1), .as(9p), .l(280.0n), .pd(31.2u),
 .ad(9p), .w(15u)) (*
integer library_binding = "gpdk090";
integer
passed_mfactor = "m";
 *)
NM10 ( net183, zero[1], top, gnd );
gpdk090_nmos2v #(.ps(31.2u), .m(1 * 1), .as(9p), .l(280.0n), .pd(31.2u),
 .ad(9p), .w(15u)) (*
integer library_binding = "gpdk090";
integer
passed_mfactor = "m";
 *)
NM11 ( bot, zero[1], net218, gnd );
gpdk090_nmos2v #(.ps(31.2u), .m(1 * 1), .as(9p), .l(280.0n), .pd(31.2u),
 .ad(9p), .w(15u)) (*
integer library_binding = "gpdk090";
integer
passed_mfactor = "m";
 *)
NM12 ( net191, zero[2], top, gnd );
gpdk090_nmos2v #(.ps(31.2u), .m(1 * 1), .as(9p), .l(280.0n), .pd(31.2u),
 .ad(9p), .w(15u)) (*
integer library_binding = "gpdk090";
integer
passed_mfactor = "m";
 *)
NM13 ( bot, zero[2], net230, gnd );
gpdk090_nmos2v #(.ps(31.2u), .m(1 * 1), .as(9p), .l(280.0n), .pd(31.2u),
 .ad(9p), .w(15u)) (*
integer library_binding = "gpdk090";
integer
passed_mfactor = "m";
 *)
NM14 ( net199, zero[3], top, gnd );
gpdk090_nmos2v #(.ps(31.2u), .m(1 * 1), .as(9p), .l(280.0n), .pd(31.2u),
 .ad(9p), .w(15u)) (*
integer library_binding = "gpdk090";
integer
passed_mfactor = "m";
 *)
NM15 ( bot, zero[3], net234, gnd );

endmodule
