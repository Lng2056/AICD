// Verilog-AMS netlist generated by the AMS netlister, version ICOA5.2.51.500.7.
// Cadence Design Systems, Inc.

`include "disciplines.vams"

module adc_wo_decode ( TEST_INM,INP,SIDDQ,TEST_ENABLE,ph1b,I100_ext2,
I100_ext1,adcflash_out,VDD,I100_poly1,BASEFX_DIS,ph1,adc_out,CLK,INM,
TEST_INP,FX_BIT,VSS,I100_poly2 );

input   TEST_INM;
input   INP;
input   SIDDQ;
input   TEST_ENABLE;

output   ph1b;
input   I100_ext2;
input   I100_ext1;
output [5:0]
 adcflash_out;
input   VDD;
input   I100_poly1;
input   BASEFX_DIS;

output   ph1;
output [62:0]  adc_out;
input   CLK;
input   INM;

input   TEST_INP;
output   FX_BIT;
input   VSS;
input   I100_poly2;

adc_clk_nonoverlap (*
integer library_binding = "ether";
 *)

ADC_CLK_NONOVERLAP ( .hold_f( hold_f ), .clk_in( CLK ), .hold_test(
hold_test ), .SIDDQ( SIDDQ ), .TEST_ENABLE( TEST_ENABLE ), .ph2( ph2 ),
.ph1b( ph1b ), .sample_test( sample_test ), .sample( sample ), .VDD(
VDD ), .ph2b( ph2b ), .sample_f( sample_f ), .ph1( ph1 ), .hold_test_f(
hold_test_f ), .hold( hold ), .sample_test_f( sample_test_f ), .VSS(
VSS ) );

adcflash (*
integer library_binding = "ether";
 *)
ADCFLASH ( .SIDDQ(
SIDDQ ), .hold_test( hold_test_f ), .inp( INP ), .sample_test(
sample_test_f ), .i1000_poly( BIAS1000f ), .inm_test( TEST_INM ), .sample(
sample_f ), .VDD( VDD ), .ph2b( ph1b ), .BASEFX_DIS( BASEFX_DIS ), .inm(
INM ), .ph1( ph2 ), .out( adcflash_out[5:0] ), .hold( hold_f ), .ibias50_ext(
BIAS50f ), .FX_BIT( FX_BIT ), .bias100( BIAS100f ), .VSS( VSS ), .inp_test(
TEST_INP ), .bias100_ext( BIAS100fSH ) );

adc (*
integer library_binding = "ether";
 *)
ADC ( .INM_TEST(
TEST_INM ), .INP_TEST( TEST_INP ), .INP( INP ), .ibias100C( BIAS100C ),
.hold_test( hold_test ), .SIDDQ( SIDDQ ), .sample_test( sample_test ),
.ref_ladder_100uA( BIAS100RL ), .ibias100B( BIAS100B ), .ibias100G(
BIAS100G ), .ibias100E( BIAS100E ), .sample( sample ), .VDD( VDD ), .ibias100D(
BIAS100D ), .ph2b( ph2b ), .ph1( ph1 ), .out( adc_out[62:0] ), .ibias100A(
BIAS100A ), .ibias100V( BIAS100V ), .hold( hold ), .INM( INM ), .ibias100(
BIAS100Z ), .ibias100H( BIAS100H ), .VSS( VSS ), .ibias50Y( BIAS50Y ),
.ibias100F( BIAS100F ) );

adc_IREF_poly (*
integer library_binding = "ether";
 *)
ADC_IREF_POLY
 ( .SIDDQ( SIDDQ ), .BIAS100RL( BIAS100RL ), .BIAS1000Z( BIAS1000f ),
.BIAS100INT( BIAS100Z ), .VDD( VDD ), .I100_poly1( I100_poly1 ), .I100_poly2(
I100_poly2 ), .VSS( VSS ) );

adc_IREF_ext (*
integer library_binding = "ether";
 *)
ADC_IREF_EXT (
.BIAS100Z( net107 ), .SIDDQ( SIDDQ ), .BIAS100V( BIAS100V ), .BIAS100fB(
BIAS100fSH ), .BIAS100F( BIAS100F ), .BIAS100C( BIAS100C ), .BIAS100A(
BIAS100A ), .I100_ext2( I100_ext2 ), .BIAS100H( BIAS100H ), .I100_ext1(
I100_ext1 ), .BIAS50f( BIAS50f ), .VDD( VDD ), .BIAS100B( BIAS100B ),
.BIAS50Y( BIAS50Y ), .BIAS100G( BIAS100G ), .VSS( VSS ), .BIAS100E(
BIAS100E ), .BIAS100fA( BIAS100f ), .BIAS100D( BIAS100D ) );

endmodule
