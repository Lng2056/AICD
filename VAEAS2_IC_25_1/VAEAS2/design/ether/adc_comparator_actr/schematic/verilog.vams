// Verilog-AMS netlist generated by the AMS netlister, version ICOA5.2.51.500.7.
// Cadence Design Systems, Inc.

`include "disciplines.vams"

module adc_comparator_actr ( outp,SIDDQ,VDD,VSS,Vbias,inm,inp,ph1,ph2b );

output   outp;
input   SIDDQ;
input   VDD;
input   VSS;
input
 Vbias;
input   inm;
input   inp;
input   ph1;
input   ph2b;

parameter min_ibias=0.00015;
parameter max_ibias=0.00025;

gpdk090_resnsppoly #(.w(2u), .r(799.766), .l(3.985u)) (*
integer
library_binding = "gpdk090";
 *)
R2 ( VDD, net0112, VDD );
gpdk090_resnsppoly #(.w(2u), .r(799.766), .l(3.985u)) (*
integer
library_binding = "gpdk090";
 *)
R3 ( VDD, net0109, VDD );
gpdk090_resnsppoly #(.w(2u), .r(799.766), .l(3.985u)) (*
integer
library_binding = "gpdk090";
 *)
R0 ( net0112, ampm, VDD );
gpdk090_resnsppoly #(.w(2u), .r(799.766), .l(3.985u)) (*
integer
library_binding = "gpdk090";
 *)
R1 ( net0109, ampp, VDD );

gpdk090_nmos2v #(.ps(21.2u), .m(1 * 1), .as(6p), .l(1u), .pd(21.2u), .ad(6p),
 .w(10u)) (*
integer library_binding = "gpdk090";
integer
passed_mfactor = "m";
 *)
NM6 ( VSS, VSS, VSS, VSS );
gpdk090_nmos2v #(.ps(19.87u), .m(1 * 1), .as(5.601p), .l(280.0n), .pd(19.87u),
 .ad(5.601p), .w(9.335u)) (*
integer library_binding = "gpdk090";

integer passed_mfactor = "m";
 *)
NM0 ( a0, b0, net28, VSS );
gpdk090_nmos2v #(.ps(21.2u), .m(1 * 1), .as(6p), .l(280.0n), .pd(21.2u),
 .ad(6p), .w(10u)) (*
integer library_binding = "gpdk090";
integer
passed_mfactor = "m";
 *)
NM1 ( net28, ph1, VSS, VSS );
gpdk090_nmos2v #(.ps(19.87u), .m(1 * 1), .as(5.601p), .l(280.0n), .pd(19.87u),
 .ad(5.601p), .w(9.335u)) (*
integer library_binding = "gpdk090";

integer passed_mfactor = "m";
 *)
NM2 ( b0, a0, net28, VSS );
gpdk090_nmos2v #(.ps(12.9u), .m(2 * 4), .as(3.6p), .l(280.0n), .pd(8.6u),
 .ad(2.4p), .w(8u)) (*
integer library_binding = "gpdk090";
integer
passed_mfactor = "m";
 *)
NM3 ( ampm, inp, net73, VSS );
gpdk090_nmos2v #(.ps(12.9u), .m(2 * 4), .as(3.6p), .l(280.0n), .pd(8.6u),
 .ad(2.4p), .w(8u)) (*
integer library_binding = "gpdk090";
integer
passed_mfactor = "m";
 *)
NM4 ( ampp, inm, net73, VSS );
gpdk090_nmos2v #(.ps(21.2u), .m(1 * 2), .as(6p), .l(1u), .pd(10.6u), .ad(3p),
 .w(10u)) (*
integer library_binding = "gpdk090";
integer
passed_mfactor = "m";
 *)
NM5 ( net73, Vbias, VSS, VSS );
gpdk090_nmos2v #(.ps(10.32u), .m(1 * 5), .as(2.88p), .l(1u), .pd(10.32u),
 .ad(2.88p), .w(8u)) (*
integer library_binding = "gpdk090";
integer
passed_mfactor = "m";
 *)
NM11 ( VSS, VDD, VSS, VSS );
gpdk090_nmos2v #(.ps(21.2u), .m(1 * 1), .as(6p), .l(1u), .pd(21.2u), .ad(6p),
 .w(10u)) (*
integer library_binding = "gpdk090";
integer
passed_mfactor = "m";
 *)
NM10 ( VSS, VSS, VSS, VSS );

gpdk090_pmos2v #(.ps(19.87u), .m(1 * 2), .as(5.601p), .l(280.0n), .pd(9.935u),
 .ad(2.8005p), .w(9.335u)) (*
integer library_binding = "gpdk090";

integer passed_mfactor = "m";
 *)
PM0 ( a0, b0, VDD, VDD );
gpdk090_pmos2v #(.ps(19.87u), .m(1 * 2), .as(5.601p), .l(280.0n), .pd(9.935u),
 .ad(2.8005p), .w(9.335u)) (*
integer library_binding = "gpdk090";

integer passed_mfactor = "m";
 *)
PM2 ( b0, a0, VDD, VDD );
gpdk090_pmos2v #(.ps(21.2u), .m(1 * 1), .as(6p), .l(280.0n), .pd(21.2u),
 .ad(6p), .w(10u)) (*
integer library_binding = "gpdk090";
integer
passed_mfactor = "m";
 *)
PM3 ( b0, ph2b, ampp, VDD );
gpdk090_pmos2v #(.ps(21.2u), .m(1 * 1), .as(6p), .l(280.0n), .pd(21.2u),
 .ad(6p), .w(10u)) (*
integer library_binding = "gpdk090";
integer
passed_mfactor = "m";
 *)
PM11 ( a0, ph2b, ampm, VDD );

clkbuf_8x_hv (*
integer library_binding = "ether";
integer cds_net_set
[0:1] = { "DVDD","DVSS" };
integer DVDD = "VDD";
integer DVSS
 = "VSS";
 *)
I22 ( .Y( outp ), .A( net094 ) );
clkbuf_8x_hv (*
integer library_binding = "ether";
integer cds_net_set
[0:1] = { "DVDD","DVSS" };
integer DVDD = "VDD";
integer DVSS
 = "VSS";
 *)
I23 ( .Y( net047 ), .A( net091 ) );

nand2_2x_hv (*
integer library_binding = "ether";
integer cds_net_set
[0:1] = { "DVSS","DVDD" };
integer DVSS = "VSS";
integer DVDD
 = "VDD";
 *)
I20 ( .Y( net094 ), .B( a0 ), .A( net091 ) );
nand2_2x_hv (*
integer library_binding = "ether";
integer cds_net_set
[0:1] = { "DVSS","DVDD" };
integer DVSS = "VSS";
integer DVDD
 = "VDD";
 *)
I21 ( .Y( net091 ), .B( b0 ), .A( net094 ) );

capacitor #(.c(17.2f)) (*
integer library_binding = "analogLib";
 *)

C4 ( inp, VSS );
capacitor #(.c(22.1f)) (*
integer library_binding = "analogLib";
 *)

C3 ( ampm, VSS );
capacitor #(.c(22.3f)) (*
integer library_binding = "analogLib";
 *)

C2 ( ampp, VSS );
capacitor #(.c(4.4f)) (*
integer library_binding = "analogLib";
 *)
C6
 ( net091, VSS );
capacitor #(.c(17.3f)) (*
integer library_binding = "analogLib";
 *)

C5 ( inm, VSS );
capacitor #(.c(4.4f)) (*
integer library_binding = "analogLib";
 *)
C7
 ( net094, VSS );
capacitor #(.c(8.9f)) (*
integer library_binding = "analogLib";
 *)
C8
 ( net28, VSS );
capacitor #(.c(25.7f)) (*
integer library_binding = "analogLib";
 *)

C9 ( net73, VSS );
capacitor #(.c(6.3f)) (*
integer library_binding = "analogLib";
 *)

C10 ( net0112, VSS );
capacitor #(.c(6.3f)) (*
integer library_binding = "analogLib";
 *)

C11 ( net0109, VSS );
capacitor #(.c(15.5f)) (*
integer library_binding = "analogLib";
 *)

C0 ( b0, VSS );
capacitor #(.c(16.2f)) (*
integer library_binding = "analogLib";
 *)

C1 ( a0, VSS );

endmodule
