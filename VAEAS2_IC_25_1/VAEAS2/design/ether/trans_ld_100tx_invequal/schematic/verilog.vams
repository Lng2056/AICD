// Verilog-AMS netlist generated by the AMS netlister, version ICOA5.2.51.500.7.
// Cadence Design Systems, Inc.

`include "disciplines.vams"

module trans_ld_100tx_invequal ( out_inv,VDD,in,out,VSS );

output   out_inv;
input   VDD;
input   in;
output   out;
input
 VSS;

gpdk090_pmos2v #(.ps(8.2u), .m(1 * 1), .as(2.1p), .l(280.0n), .pd(8.2u),
 .ad(2.1p), .w(3.5u)) (*
integer library_binding = "gpdk090";
integer
passed_mfactor = "m";
 *)
PM3 ( net1, net22, VDD, VDD );
gpdk090_pmos2v #(.ps(8.2u), .m(1 * 1), .as(2.1p), .l(280.0n), .pd(8.2u),
 .ad(2.1p), .w(3.5u)) (*
integer library_binding = "gpdk090";
integer
passed_mfactor = "m";
 *)
M0 ( net053, VSS, net18, VDD );

gpdk090_nmos2v #(.ps(3.53u), .m(1 * 1), .as(699f), .l(280.0n), .pd(3.53u),
 .ad(699f), .w(1.165u)) (*
integer library_binding = "gpdk090";

integer passed_mfactor = "m";
 *)
M1 ( net053, VDD, net18, VSS );
gpdk090_nmos2v #(.ps(3.53u), .m(1 * 1), .as(699f), .l(280.0n), .pd(3.53u),
 .ad(699f), .w(1.165u)) (*
integer library_binding = "gpdk090";

integer passed_mfactor = "m";
 *)
NM3 ( net1, net22, VSS, VSS );

trans_clkinv_1X #(.ieLib("umc05001")) (*
integer library_binding
 = "ether";
integer cds_net_set[0:1] = { "DVSS","DVDD" };
integer DVSS
 = "VSS";
integer DVDD = "VDD";
 *)
I35 ( .Vgnd( VSS ), .in( net1 ), .out(
net041 ), .Vpwr( VDD ) );
trans_clkinv_1X (*
integer library_binding = "ether";
 *)
I34 ( .Vgnd(
VSS ), .in( net053 ), .out( net037 ), .Vpwr( VDD ) );

trans_clkinv_2X (*
integer library_binding = "ether";
 *)
I32 ( .Vgnd(
VSS ), .in( in ), .out( net18 ), .Vpwr( VDD ) );
trans_clkinv_2X (*
integer library_binding = "ether";
 *)
I33 ( .Vgnd(
VSS ), .in( in ), .out( net22 ), .Vpwr( VDD ) );

trans_inv_16X #(.ieLib("umc05001")) (*
integer library_binding
 = "ether";
integer cds_net_set[0:1] = { "DVSS","DVDD" };
integer DVSS
 = "VSS";
integer DVDD = "VDD";
 *)
I41 ( .Vgnd( VSS ), .in( net065 ),
.out( out_inv ), .Vpwr( VDD ) );
trans_inv_16X #(.ieLib("umc05001")) (*
integer library_binding
 = "ether";
integer cds_net_set[0:1] = { "DVDD","DVSS" };
integer DVDD
 = "VDD";
integer DVSS = "VSS";
 *)
I40 ( .Vgnd( VSS ), .in( net061 ),
.out( out ), .Vpwr( VDD ) );

trans_inv_8X #(.ieLib("umc05001")) (*
integer library_binding
 = "ether";
integer cds_net_set[0:1] = { "DVDD","DVSS" };
integer DVDD
 = "VDD";
integer DVSS = "VSS";
 *)
I38 ( .Vgnd( VSS ), .in( net069 ),
.out( net061 ), .Vpwr( VDD ) );
trans_inv_8X #(.ieLib("umc05001")) (*
integer library_binding
 = "ether";
integer cds_net_set[0:1] = { "DVDD","DVSS" };
integer DVDD
 = "VDD";
integer DVSS = "VSS";
 *)
I39 ( .Vgnd( VSS ), .in( net073 ),
.out( net065 ), .Vpwr( VDD ) );

trans_inv_4X #(.ieLib("umc05001")) (*
integer library_binding
 = "ether";
integer cds_net_set[0:1] = { "DVDD","DVSS" };
integer DVDD
 = "VDD";
integer DVSS = "VSS";
 *)
I36 ( .Vgnd( VSS ), .in( net037 ),
.out( net069 ), .Vpwr( VDD ) );
trans_inv_4X #(.ieLib("umc05001")) (*
integer library_binding
 = "ether";
integer cds_net_set[0:1] = { "DVDD","DVSS" };
integer DVDD
 = "VDD";
integer DVSS = "VSS";
 *)
I37 ( .Vgnd( VSS ), .in( net041 ),
.out( net073 ), .Vpwr( VDD ) );

endmodule
