// Verilog-AMS netlist generated by the AMS netlister, version ICOA5.2.51.500.7.
// Cadence Design Systems, Inc.

`include "disciplines.vams"

module blw_dac_new_bias ( I_rpoly_100_2,AVDD_2p5V,I_rpoly_100_1,
vbiasn_bit,ibiasp_output,ibiasp_bit,agnd,siddq,vbiasnc_bit,
ibiaspc_output );

input   I_rpoly_100_2;
input   AVDD_2p5V;
input   I_rpoly_100_1;

output   vbiasn_bit;
output   ibiasp_output;
output   ibiasp_bit;

input   agnd;
input   siddq;
output   vbiasnc_bit;
output
 ibiaspc_output;

gpdk090_pmos2v #(.ps(11.2u), .m(1 * 2), .as(3p), .l(300n), .pd(5.6u),
.ad(1.5p), .w(5u)) (*
integer library_binding = "gpdk090";
integer
passed_mfactor = "m";
 *)
PM0 ( vbiasnc_bit, siddq, I_rpoly_100_1,
AVDD_2p5V );
gpdk090_pmos2v #(.ps(11.2u), .m(1 * 2), .as(3p), .l(300n), .pd(5.6u),
.ad(1.5p), .w(5u)) (*
integer library_binding = "gpdk090";
integer
passed_mfactor = "m";
 *)
PM1 ( vbiasn_bit, siddq, I_rpoly_100_2,
AVDD_2p5V );

gpdk090_nmos2v #(.ps(8.4u), .m(1 * 4), .as(2.25p), .l(350.0n), .pd(5.6u),
 .ad(1.5p), .w(5u)) (*
integer library_binding = "gpdk090";
integer
passed_mfactor = "m";
 *)
NM1 ( ibiaspc_output, vbiasnc_bit, net0248,
agnd );
gpdk090_nmos2v #(.ps(7.46667u), .m(1 * 3), .as(2p), .l(5u), .pd(7.46667u),
 .ad(2p), .w(5u)) (*
integer library_binding = "gpdk090";
integer
passed_mfactor = "m";
 *)
NM9 ( net0251, vbiasnc_bit, agnd, agnd );
gpdk090_nmos2v #(.ps(8.4u), .m(1 * 4), .as(2.25p), .l(350.0n), .pd(5.6u),
 .ad(1.5p), .w(5u)) (*
integer library_binding = "gpdk090";
integer
passed_mfactor = "m";
 *)
NM54 ( ibiasp_output, vbiasnc_bit, net202,
agnd );
gpdk090_nmos2v #(.ps(8.4u), .m(1 * 4), .as(2.25p), .l(5u), .pd(5.6u),
.ad(1.5p), .w(5u)) (*
integer library_binding = "gpdk090";
integer
passed_mfactor = "m";
 *)
NM53 ( net202, vbiasn_bit, agnd, agnd );
gpdk090_nmos2v #(.ps(8.4u), .m(1 * 4), .as(2.25p), .l(5u), .pd(5.6u),
.ad(1.5p), .w(5u)) (*
integer library_binding = "gpdk090";
integer
passed_mfactor = "m";
 *)
NM55 ( net0248, vbiasn_bit, agnd, agnd );
gpdk090_nmos2v #(.ps(3.2u), .m(1 * 1), .as(600f), .l(350.0n), .pd(3.2u),
 .ad(600f), .w(1u)) (*
integer library_binding = "gpdk090";
integer
passed_mfactor = "m";
 *)
NM56 ( vbiasnc_bit, siddq, agnd, agnd );
gpdk090_nmos2v #(.ps(7.46667u), .m(1 * 3), .as(2p), .l(350.0n), .pd(7.46667u),
 .ad(2p), .w(5u)) (*
integer library_binding = "gpdk090";
integer
passed_mfactor = "m";
 *)
NM10 ( vbiasnc_bit, vbiasnc_bit, net0251,
agnd );
gpdk090_nmos2v #(.ps(3.2u), .m(1 * 1), .as(600f), .l(350.0n), .pd(3.2u),
 .ad(600f), .w(1u)) (*
integer library_binding = "gpdk090";
integer
passed_mfactor = "m";
 *)
NM60 ( vbiasn_bit, siddq, agnd, agnd );
gpdk090_nmos2v #(.ps(11.2u), .m(1 * 2), .as(3p), .l(5u), .pd(5.6u), .ad(1.5p),
 .w(5u)) (*
integer library_binding = "gpdk090";
integer
passed_mfactor = "m";
 *)
NM7 ( net242, vbiasn_bit, agnd, agnd );
gpdk090_nmos2v #(.ps(11.2u), .m(1 * 2), .as(3p), .l(350.0n), .pd(5.6u),
 .ad(1.5p), .w(5u)) (*
integer library_binding = "gpdk090";
integer
passed_mfactor = "m";
 *)
NM8 ( ibiasp_bit, vbiasnc_bit, net242, agnd );
gpdk090_nmos2v #(.ps(6.72u), .m(1 * 10), .as(1.8p), .l(5u), .pd(5.6u),
 .ad(1.5p), .w(5u)) (*
integer library_binding = "gpdk090";
integer
passed_mfactor = "m";
 *)
NM13 ( net258, vbiasn_bit, agnd, agnd );
gpdk090_nmos2v #(.ps(6.72u), .m(1 * 10), .as(1.8p), .l(350.0n), .pd(5.6u),
 .ad(1.5p), .w(5u)) (*
integer library_binding = "gpdk090";
integer
passed_mfactor = "m";
 *)
NM12 ( vbiasn_bit, vbiasnc_bit, net258, agnd );
gpdk090_nmos2v #(.ps(3.2u), .m(1 * 1), .as(600f), .l(350.0n), .pd(3.2u),
 .ad(600f), .w(1u)) (*
integer library_binding = "gpdk090";
integer
passed_mfactor = "m";
 *)
NM2 ( vbiasnc_bit, siddq, agnd, agnd );
gpdk090_nmos2v #(.ps(3.2u), .m(1 * 1), .as(600f), .l(350.0n), .pd(3.2u),
 .ad(600f), .w(1u)) (*
integer library_binding = "gpdk090";
integer
passed_mfactor = "m";
 *)
NM19 ( ibiasp_bit, siddq, agnd, agnd );

endmodule
