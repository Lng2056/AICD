// Verilog-AMS netlist generated by the AMS netlister, version ICOA5.2.51.500.7.
// Cadence Design Systems, Inc.

`include "disciplines.vams"

module Analog_eq_bias ( I_rext_100_2,avdd,I_rext_100_4,Vbiasn3,vbiasnc,
vbiaspc,I_rext_100_3,vbiasn,Vbiasp2,I_rext_100_1,vbiasp,agnd,siddq,
vbiasn2 );

input   I_rext_100_2;
inout   avdd;
input   I_rext_100_4;
output
 Vbiasn3;
output   vbiasnc;
output   vbiaspc;
input   I_rext_100_3;

output   vbiasn;
output   Vbiasp2;
input   I_rext_100_1;
output
 vbiasp;
input   agnd;
input   siddq;
output   vbiasn2;

gpdk090_resnsppoly #(.w(2u), .r(100.01K), .l(500.079u)) (*
integer
library_binding = "gpdk090";
 *)
R2 ( net0136, Vbiasn3, agnd );
gpdk090_resnsppoly #(.w(2u), .r(100.002K), .l(500.029u)) (*
integer
library_binding = "gpdk090";
 *)
R1 ( vbiasn, net207, agnd );
gpdk090_resnsppoly #(.w(2u), .r(100.002K), .l(500.029u)) (*
integer
library_binding = "gpdk090";
 *)
R0 ( net144, vbiasn2, agnd );

gpdk090_pmos2v #(.ps(12.4u), .m(1 * 2), .as(3.36p), .l(280.0n), .pd(6.2u),
 .ad(1.68p), .w(5.6u)) (*
integer library_binding = "gpdk090";

integer passed_mfactor = "m";
 *)
PM2 ( vbiaspc, vbiaspc, net0245,
avdd );
gpdk090_pmos2v #(.ps(3.53u), .m(1 * 1), .as(699f), .l(280.0n), .pd(3.53u),
 .ad(699f), .w(1.165u)) (*
integer library_binding = "gpdk090";

integer passed_mfactor = "m";
 *)
PM6 ( Vbiasp2, xsiddq, avdd, avdd );
gpdk090_pmos2v #(.ps(30.9u), .m(1 * 4), .as(9p), .l(2u), .pd(20.6u), .ad(6p),
 .w(20u)) (*
integer library_binding = "gpdk090";
integer
passed_mfactor = "m";
 *)
PM33 ( vbiasnc, net225, avdd, avdd );
gpdk090_pmos2v #(.ps(30.9u), .m(1 * 4), .as(9p), .l(2u), .pd(20.6u), .ad(6p),
 .w(20u)) (*
integer library_binding = "gpdk090";
integer
passed_mfactor = "m";
 *)
PM32 ( net225, net225, avdd, avdd );
gpdk090_pmos2v #(.ps(3.53u), .m(1 * 1), .as(699f), .l(280.0n), .pd(3.53u),
 .ad(699f), .w(1.165u)) (*
integer library_binding = "gpdk090";

integer passed_mfactor = "m";
 *)
PM14 ( vbiaspc, xsiddq, avdd, avdd );
gpdk090_pmos2v #(.ps(17.7u), .m(1 * 4), .as(5.04p), .l(280.0n), .pd(11.8u),
 .ad(3.36p), .w(11.2u)) (*
integer library_binding = "gpdk090";

integer passed_mfactor = "m";
 *)
PM10 ( vbiasp, vbiaspc, net264, avdd );
gpdk090_pmos2v #(.ps(3.53u), .m(1 * 1), .as(699f), .l(280.0n), .pd(3.53u),
 .ad(699f), .w(1.165u)) (*
integer library_binding = "gpdk090";

integer passed_mfactor = "m";
 *)
PM55 ( net225, xsiddq, avdd, avdd );
gpdk090_pmos2v #(.ps(20.75u), .m(4 * 8), .as(6p), .l(5u), .pd(16.6u),
.ad(4.8p), .w(16u)) (*
integer library_binding = "gpdk090";
integer
passed_mfactor = "m";
 *)
PM5 ( Vbiasp2, Vbiasp2, avdd, avdd );
gpdk090_pmos2v #(.ps(3.53u), .m(1 * 1), .as(699f), .l(280.0n), .pd(3.53u),
 .ad(699f), .w(1.165u)) (*
integer library_binding = "gpdk090";

integer passed_mfactor = "m";
 *)
PM7 ( vbiasp, xsiddq, avdd, avdd );
gpdk090_pmos2v #(.ps(10.32u), .m(1 * 5), .as(2.88p), .l(800n), .pd(10.32u),
 .ad(2.88p), .w(8u)) (*
integer library_binding = "gpdk090";
integer
passed_mfactor = "m";
 *)
PM12 ( net264, vbiasp, avdd, avdd );
gpdk090_pmos2v #(.ps(12.4u), .m(1 * 2), .as(3.36p), .l(280.0n), .pd(6.2u),
 .ad(1.68p), .w(5.6u)) (*
integer library_binding = "gpdk090";

integer passed_mfactor = "m";
 *)
PM16 ( net284, vbiaspc, avdd, avdd );
gpdk090_pmos2v #(.ps(12.4u), .m(1 * 2), .as(3.36p), .l(280.0n), .pd(6.2u),
 .ad(1.68p), .w(5.6u)) (*
integer library_binding = "gpdk090";

integer passed_mfactor = "m";
 *)
PM17 ( net0245, vbiaspc, net284,
avdd );

gpdk090_nmos2v #(.ps(21.2u), .m(1 * 1), .as(6p), .l(280.0n), .pd(21.2u),
 .ad(6p), .w(10u)) (*
integer library_binding = "gpdk090";
integer
passed_mfactor = "m";
 *)
NM19 ( I_rext_100_4, xsiddq, net0136, agnd );
gpdk090_nmos2v #(.ps(8.82u), .m(1 * 1), .as(2.286p), .l(280.0n), .pd(8.82u),
 .ad(2.286p), .w(3.81u)) (*
integer library_binding = "gpdk090";

integer passed_mfactor = "m";
 *)
NM0 ( vbiasnc, vbiasnc, net165, agnd );
gpdk090_nmos2v #(.ps(3.53u), .m(1 * 1), .as(699f), .l(280.0n), .pd(3.53u),
 .ad(699f), .w(1.165u)) (*
integer library_binding = "gpdk090";

integer passed_mfactor = "m";
 *)
NM20 ( Vbiasn3, siddq, agnd, agnd );
gpdk090_nmos2v #(.ps(21.2u), .m(1 * 1), .as(6p), .l(1u), .pd(21.2u), .ad(6p),
 .w(10u)) (*
integer library_binding = "gpdk090";
integer
passed_mfactor = "m";
 *)
NM18 ( Vbiasp2, net0136, agnd, agnd );
gpdk090_nmos2v #(.ps(3.53u), .m(1 * 1), .as(699f), .l(280.0n), .pd(3.53u),
 .ad(699f), .w(1.165u)) (*
integer library_binding = "gpdk090";

integer passed_mfactor = "m";
 *)
NM11 ( vbiasn, siddq, agnd, agnd );
gpdk090_nmos2v #(.ps(3.53u), .m(1 * 1), .as(699f), .l(280.0n), .pd(3.53u),
 .ad(699f), .w(1.165u)) (*
integer library_binding = "gpdk090";

integer passed_mfactor = "m";
 *)
NM58 ( net169, siddq, agnd, agnd );
gpdk090_nmos2v #(.ps(8.82u), .m(1 * 1), .as(2.286p), .l(280.0n), .pd(8.82u),
 .ad(2.286p), .w(3.81u)) (*
integer library_binding = "gpdk090";

integer passed_mfactor = "m";
 *)
NM1 ( net165, vbiasnc, agnd, agnd );
gpdk090_nmos2v #(.ps(11.2u), .m(2 * 2), .as(3p), .l(1u), .pd(5.6u), .ad(1.5p),
 .w(5u)) (*
integer library_binding = "gpdk090";
integer
passed_mfactor = "m";
 *)
NM32 ( net169, net169, agnd, agnd );
gpdk090_nmos2v #(.ps(3.53u), .m(1 * 1), .as(699f), .l(280.0n), .pd(3.53u),
 .ad(699f), .w(1.165u)) (*
integer library_binding = "gpdk090";

integer passed_mfactor = "m";
 *)
NM10 ( vbiasn2, siddq, agnd, agnd );
gpdk090_nmos2v #(.ps(21.2u), .m(1 * 1), .as(6p), .l(280.0n), .pd(21.2u),
 .ad(6p), .w(10u)) (*
integer library_binding = "gpdk090";
integer
passed_mfactor = "m";
 *)
NM15 ( I_rext_100_2, xsiddq, net207, agnd );
gpdk090_nmos2v #(.ps(21.2u), .m(1 * 1), .as(6p), .l(280.0n), .pd(21.2u),
 .ad(6p), .w(10u)) (*
integer library_binding = "gpdk090";
integer
passed_mfactor = "m";
 *)
NM9 ( I_rext_100_3, xsiddq, net144, agnd );
gpdk090_nmos2v #(.ps(21.2u), .m(1 * 1), .as(6p), .l(1u), .pd(21.2u), .ad(6p),
 .w(10u)) (*
integer library_binding = "gpdk090";
integer
passed_mfactor = "m";
 *)
NM14 ( net0136, net0136, agnd, agnd );
gpdk090_nmos2v #(.ps(25.2u), .m(1 * 2), .as(7.2p), .l(1u), .pd(12.6u),
 .ad(3.6p), .w(12u)) (*
integer library_binding = "gpdk090";
integer
passed_mfactor = "m";
 *)
NM7 ( net189, vbiasn, agnd, agnd );
gpdk090_nmos2v #(.ps(19.12u), .m(1 * 2), .as(5.376p), .l(280.0n), .pd(9.56u),
 .ad(2.688p), .w(8.96u)) (*
integer library_binding = "gpdk090";

integer passed_mfactor = "m";
 *)
NM8 ( vbiasp, vbiasnc, net189, agnd );
gpdk090_nmos2v #(.ps(19.12u), .m(1 * 2), .as(5.376p), .l(280.0n), .pd(9.56u),
 .ad(2.688p), .w(8.96u)) (*
integer library_binding = "gpdk090";

integer passed_mfactor = "m";
 *)
NM16 ( vbiaspc, vbiasnc, net201,
agnd );
gpdk090_nmos2v #(.ps(25.2u), .m(1 * 2), .as(7.2p), .l(1u), .pd(12.6u),
 .ad(3.6p), .w(12u)) (*
integer library_binding = "gpdk090";
integer
passed_mfactor = "m";
 *)
NM17 ( net201, vbiasn, agnd, agnd );
gpdk090_nmos2v #(.ps(25.2u), .m(1 * 2), .as(7.2p), .l(1u), .pd(12.6u),
 .ad(3.6p), .w(12u)) (*
integer library_binding = "gpdk090";
integer
passed_mfactor = "m";
 *)
NM13 ( net205, net207, agnd, agnd );
gpdk090_nmos2v #(.ps(19.12u), .m(1 * 2), .as(5.376p), .l(280.0n), .pd(9.56u),
 .ad(2.688p), .w(8.96u)) (*
integer library_binding = "gpdk090";

integer passed_mfactor = "m";
 *)
NM12 ( net207, vbiasnc, net205, agnd );
gpdk090_nmos2v #(.ps(21.2u), .m(1 * 1), .as(6p), .l(280.0n), .pd(21.2u),
 .ad(6p), .w(10u)) (*
integer library_binding = "gpdk090";
integer
passed_mfactor = "m";
 *)
NM50 ( I_rext_100_1, xsiddq, net169, agnd );
gpdk090_nmos2v #(.ps(11.2u), .m(2 * 2), .as(3p), .l(1u), .pd(5.6u), .ad(1.5p),
 .w(5u)) (*
integer library_binding = "gpdk090";
integer
passed_mfactor = "m";
 *)
NM31 ( net225, net169, agnd, agnd );
gpdk090_nmos2v #(.ps(8.4u), .m(1 * 4), .as(2.25p), .l(1u), .pd(5.6u),
.ad(1.5p), .w(5u)) (*
integer library_binding = "gpdk090";
integer
passed_mfactor = "m";
 *)
NM6 ( net144, net144, agnd, agnd );
gpdk090_nmos2v #(.ps(3.53u), .m(1 * 1), .as(699f), .l(280.0n), .pd(3.53u),
 .ad(699f), .w(1.165u)) (*
integer library_binding = "gpdk090";

integer passed_mfactor = "m";
 *)
NM29 ( vbiasnc, siddq, agnd, agnd );

gpdk090_nmoscap2v #(.m(1 * 12), .l(11.42u), .w(11.38u)) (*
integer
library_binding = "gpdk090";
integer passed_mfactor = "m";
 *)
C2 (
agnd, Vbiasn3, agnd, agnd );
gpdk090_nmoscap2v #(.m(1 * 12), .l(11.42u), .w(11.38u)) (*
integer
library_binding = "gpdk090";
integer passed_mfactor = "m";
 *)
C1 (
agnd, vbiasn, agnd, agnd );
gpdk090_nmoscap2v #(.m(1 * 12), .l(11.42u), .w(11.38u)) (*
integer
library_binding = "gpdk090";
integer passed_mfactor = "m";
 *)
C0 (
agnd, vbiasn2, agnd, agnd );

inv_1X (*
integer library_binding = "ether";
 *)
I2 ( .vss( agnd ), .VDD(
avdd ), .in( siddq ), .out( xsiddq ) );

endmodule
