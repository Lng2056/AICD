// Verilog-AMS netlist generated by the AMS netlister, version ICOA5.2.51.500.7.
// Cadence Design Systems, Inc.

`include "disciplines.vams"

module tielo_hv ( Y );

output   Y;

wire (*
integer inh_conn_prop_name = "DVDD";
integer
inh_conn_def_value = "cds_globals.\\VDD! ";
 *)
\VDD! ;
wire (*
integer inh_conn_prop_name = "DVSS";
integer
inh_conn_def_value = "cds_globals.\\VSS! ";
 *)
\VSS! ;

gpdk090_pmos2v #(.ps(2.8u), .m(1 * 1), .as(440f), .l(280.0n), .pd(2.8u),
 .ad(440f), .w(400n)) (*
integer library_binding = "gpdk090";
integer
passed_mfactor = "m";
 *)
PM0 ( net16, net16, \VDD! , \VDD!  );

gpdk090_nmos2v #(.ps(3.6u), .m(1 * 1), .as(720f), .l(280.0n), .pd(3.6u),
 .ad(720f), .w(1.2u)) (*
integer library_binding = "gpdk090";
integer
passed_mfactor = "m";
 *)
NM0 ( Y, net16, \VSS! , \VSS!  );

endmodule
