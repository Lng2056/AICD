// Verilog-AMS netlist generated by the AMS netlister, version ICOA5.2.51.500.7.
// Cadence Design Systems, Inc.

`include "disciplines.vams"

module adcflash_therm2bin ( CLK125,THERM,BIN,BASEFX_DIS,FX_BIT );

input   CLK125;
input [5:0]  THERM;
output [2:0]  BIN;
input
 BASEFX_DIS;
input   FX_BIT;

wire n_83;
wire n_69;
wire [5:0] THERM;
wire n_89;
wire n_57;
wire n_66;
wire n_58;
wire n_88;
wire n_54;
wire n_72;
wire n_90;
wire n_41;
wire n_67;
wire n_34;
wire n_45;
wire n_76;
wire n_62;
wire n_71;
wire n_38;
wire n_99;
wire [2:0] BIN;
wire n_49;
wire n_60;
wire n_47;
wire n_81;
wire n_42;
wire n_84;
wire n_43;
wire n_77;
wire BASEFX_DIS;
wire n_98;
wire n_78;
wire n_70;
wire CLK125;
wire n_86;
wire FX_BIT;
wire n_75;
wire n_52;
wire n_97;
wire n_44;
wire n_85;
wire n_59;
wire n_63;

INVX1 (*
integer library_binding = "gsclib090";
 *)
i_131 ( .Y( n_99 ),
.A( n_41 ) );
INVX1 (*
integer library_binding = "gsclib090";
 *)
i_130 ( .Y( n_98 ),
.A( n_62 ) );
INVX1 (*
integer library_binding = "gsclib090";
 *)
i_129 ( .Y( n_97 ),
.A( n_66 ) );

DFFX1 (*
integer library_binding = "gsclib090";
 *)
BIN_reg_2 ( .QN(
net271 ), .D( n_90 ), .CK( CLK125 ), .Q( BIN[2] ) );
DFFX1 (*
integer library_binding = "gsclib090";
 *)
BIN_reg_1 ( .QN(
net275 ), .D( n_89 ), .CK( CLK125 ), .Q( BIN[1] ) );
DFFX1 (*
integer library_binding = "gsclib090";
 *)
BIN_reg_0 ( .QN(
net279 ), .D( n_88 ), .CK( CLK125 ), .Q( BIN[0] ) );

AND2X1 (*
integer library_binding = "gsclib090";
 *)
i_66 ( .Y( n_67 ),
.B( n_78 ), .A( n_81 ) );

OR2X1 (*
integer library_binding = "gsclib090";
 *)
i_5906 ( .Y( n_59 ),
.B( THERM[0] ), .A( THERM[1] ) );
OR2X1 (*
integer library_binding = "gsclib090";
 *)
i_9910 ( .Y( n_58 ),
.B( n_70 ), .A( n_97 ) );

NAND2X1 (*
integer library_binding = "gsclib090";
 *)
i_2 ( .Y( n_88 ),
.B( n_85 ), .A( BASEFX_DIS ) );
NAND2X1 (*
integer library_binding = "gsclib090";
 *)
i_30 ( .Y( n_81 ),
.B( n_47 ), .A( n_70 ) );
NAND2X1 (*
integer library_binding = "gsclib090";
 *)
i_35 ( .Y( n_78 ),
.B( n_45 ), .A( n_76 ) );
NAND2X1 (*
integer library_binding = "gsclib090";
 *)
i_38 ( .Y( n_77 ),
.B( THERM[1] ), .A( THERM[3] ) );
NAND2X1 (*
integer library_binding = "gsclib090";
 *)
i_39 ( .Y( n_76 ),
.B( THERM[2] ), .A( THERM[3] ) );
NAND2X1 (*
integer library_binding = "gsclib090";
 *)
i_44 ( .Y( n_72 ),
.B( THERM[1] ), .A( THERM[2] ) );
NAND2X1 (*
integer library_binding = "gsclib090";
 *)
i_45 ( .Y( n_71 ),
.B( n_43 ), .A( n_72 ) );
NAND2X1 (*
integer library_binding = "gsclib090";
 *)
i_5 ( .Y( n_70 ),
.B( THERM[5] ), .A( THERM[4] ) );
NAND2X1 (*
integer library_binding = "gsclib090";
 *)
i_67 ( .Y( n_66 ),
.B( n_44 ), .A( n_63 ) );
NAND2X1 (*
integer library_binding = "gsclib090";
 *)
i_71 ( .Y( n_63 ),
.B( n_75 ), .A( n_78 ) );
NAND2X1 (*
integer library_binding = "gsclib090";
 *)
i_72 ( .Y( n_62 ),
.B( n_42 ), .A( n_63 ) );
NAND2X1 (*
integer library_binding = "gsclib090";
 *)
i_22 ( .Y( n_34 ),
.B( n_83 ), .A( BASEFX_DIS ) );

NAND4X1 (*
integer library_binding = "gsclib090";
 *)
i_16 ( .D( n_59 ),
.C( n_97 ), .Y( n_84 ), .B( n_69 ), .A( n_98 ) );
NAND4X1 (*
integer library_binding = "gsclib090";
 *)
i_10 ( .D( n_58 ),
.C( n_84 ), .Y( n_83 ), .B( n_57 ), .A( n_49 ) );
NAND4X1 (*
integer library_binding = "gsclib090";
 *)
i_17 ( .D(
BASEFX_DIS ), .C( n_86 ), .Y( n_38 ), .B( n_99 ), .A( n_57 ) );

AOI21X1 (*
integer library_binding = "gsclib090";
 *)
i_14 ( .A0( n_52 ),
.A1( n_98 ), .B0( n_54 ), .Y( n_86 ) );
AOI21X1 (*
integer library_binding = "gsclib090";
 *)
i_62 ( .A0(
THERM[4] ), .A1( THERM[5] ), .B0( n_67 ), .Y( n_69 ) );
AOI21X1 (*
integer library_binding = "gsclib090";
 *)
i_77 ( .A0( n_75 ),
.A1( n_59 ), .B0( n_71 ), .Y( n_60 ) );
AOI21X1 (*
integer library_binding = "gsclib090";
 *)
i_6 ( .A0( n_81 ),
.A1( n_75 ), .B0( n_67 ), .Y( n_44 ) );

OAI21X1 (*
integer library_binding = "gsclib090";
 *)
i_0428 ( .A0(
FX_BIT ), .A1( BASEFX_DIS ), .B0( n_38 ), .Y( n_90 ) );
OAI21X1 (*
integer library_binding = "gsclib090";
 *)
i_1 ( .A0(
FX_BIT ), .A1( BASEFX_DIS ), .B0( n_34 ), .Y( n_89 ) );
OAI21X1 (*
integer library_binding = "gsclib090";
 *)
i_12 ( .A0( n_98 ),
.A1( n_60 ), .B0( n_58 ), .Y( n_41 ) );
OAI21X1 (*
integer library_binding = "gsclib090";
 *)
i_8 ( .A0( n_75 ),
.A1( n_78 ), .B0( n_71 ), .Y( n_42 ) );
OAI21X1 (*
integer library_binding = "gsclib090";
 *)
i_7 ( .A0(
THERM[1] ), .A1( THERM[2] ), .B0( THERM[0] ), .Y( n_43 ) );
OAI21X1 (*
integer library_binding = "gsclib090";
 *)
i_4 ( .A0(
THERM[2] ), .A1( THERM[3] ), .B0( THERM[4] ), .Y( n_45 ) );
OAI21X1 (*
integer library_binding = "gsclib090";
 *)
i_0 ( .A0(
THERM[5] ), .A1( THERM[4] ), .B0( THERM[3] ), .Y( n_47 ) );

NAND3X1 (*
integer library_binding = "gsclib090";
 *)
i_9 ( .C( n_86 ),
.Y( n_85 ), .B( n_49 ), .A( n_57 ) );
NAND3X1 (*
integer library_binding = "gsclib090";
 *)
i_40 ( .C( n_72 ),
.Y( n_75 ), .B( n_76 ), .A( n_77 ) );
NAND3X1 (*
integer library_binding = "gsclib090";
 *)
i_12914 ( .C(
n_62 ), .Y( n_57 ), .B( n_67 ), .A( n_70 ) );
NAND3X1 (*
integer library_binding = "gsclib090";
 *)
i_12930 ( .C(
n_97 ), .Y( n_49 ), .B( n_60 ), .A( n_59 ) );

NOR2X1 (*
integer library_binding = "gsclib090";
 *)
i_10923 ( .Y(
n_52 ), .B( n_97 ), .A( n_69 ) );
NOR2X1 (*
integer library_binding = "gsclib090";
 *)
i_14920 ( .Y(
n_54 ), .B( n_66 ), .A( n_98 ) );

endmodule
