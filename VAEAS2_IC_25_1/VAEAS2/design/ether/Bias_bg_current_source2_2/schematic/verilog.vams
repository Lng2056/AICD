// Verilog-AMS netlist generated by the AMS netlister, version ICOA5.2.51.500.7.
// Cadence Design Systems, Inc.

`include "disciplines.vams"

module Bias_bg_current_source2_2 ( I_25u_Rpoly_PLL,Vref,RPOLY_OUT,
CASC_AC_IN,vss,I_100u_Rpoly,VDD,RPOLY_IN,siddq,Ibias,CASC_AC_OUT );

output [1:0]  I_25u_Rpoly_PLL;
inout   Vref;
output   RPOLY_OUT;

input   CASC_AC_IN;
inout   vss;
output   I_100u_Rpoly;
input   VDD;

input   RPOLY_IN;
inout   siddq;
inout   Ibias;
output   CASC_AC_OUT;

gpdk090_resnsppoly #(.w(4.2u), .r(199.687), .l(2.085u)) (*
integer
library_binding = "gpdk090";
 *)
R0 ( Pbias, net0167, vss );
gpdk090_resnsppoly #(.w(2u), .r(50.0051K), .l(250.032u)) (*
integer
library_binding = "gpdk090";
 *)
R4 ( net543, net619, vss );

gpdk090_pmos2v #(.ps(81.2u), .m(4 * 1), .as(24p), .l(4u), .pd(81.2u),
.ad(24p), .w(40u)) (*
integer library_binding = "gpdk090";
integer
passed_mfactor = "m";
 *)
PM198 ( VDD, VDD, VDD, VDD );
gpdk090_pmos2v #(.ps(81.2u), .m(4 * 1), .as(24p), .l(500n), .pd(81.2u),
 .ad(24p), .w(40u)) (*
integer library_binding = "gpdk090";
integer
passed_mfactor = "m";
 *)
PM199 ( VDD, VDD, VDD, VDD );
gpdk090_pmos2v #(.ps(81.2u), .m(4 * 1), .as(24p), .l(500n), .pd(81.2u),
 .ad(24p), .w(40u)) (*
integer library_binding = "gpdk090";
integer
passed_mfactor = "m";
 *)
PM34 ( VDD, VDD, VDD, VDD );
gpdk090_pmos2v #(.ps(81.2u), .m(4 * 1), .as(24p), .l(4u), .pd(81.2u),
.ad(24p), .w(40u)) (*
integer library_binding = "gpdk090";
integer
passed_mfactor = "m";
 *)
PM35 ( VDD, VDD, VDD, VDD );
gpdk090_pmos2v #(.ps(81.2u), .m(4 * 1), .as(24p), .l(500n), .pd(81.2u),
 .ad(24p), .w(40u)) (*
integer library_binding = "gpdk090";
integer
passed_mfactor = "m";
 *)
PM33 ( RPOLY_OUT, Pcasc, net716, net716 );
gpdk090_pmos2v #(.ps(81.2u), .m(4 * 1), .as(24p), .l(4u), .pd(81.2u),
.ad(24p), .w(40u)) (*
integer library_binding = "gpdk090";
integer
passed_mfactor = "m";
 *)
PM36 ( net708, Pbias, VDD, VDD );
gpdk090_pmos2v #(.ps(81.2u), .m(4 * 1), .as(24p), .l(500n), .pd(81.2u),
 .ad(24p), .w(40u)) (*
integer library_binding = "gpdk090";
integer
passed_mfactor = "m";
 *)
PM37 ( net623, Pcasc, net708, net708 );
gpdk090_pmos2v #(.ps(81.2u), .m(4 * 1), .as(24p), .l(500n), .pd(81.2u),
 .ad(24p), .w(40u)) (*
integer library_binding = "gpdk090";
integer
passed_mfactor = "m";
 *)
PM38 ( net619, Pcasc, net704, net704 );
gpdk090_pmos2v #(.ps(81.2u), .m(4 * 1), .as(24p), .l(4u), .pd(81.2u),
.ad(24p), .w(40u)) (*
integer library_binding = "gpdk090";
integer
passed_mfactor = "m";
 *)
PM39 ( net704, Pbias, VDD, VDD );
gpdk090_pmos2v #(.ps(81.2u), .m(4 * 1), .as(24p), .l(4u), .pd(81.2u),
.ad(24p), .w(40u)) (*
integer library_binding = "gpdk090";
integer
passed_mfactor = "m";
 *)
PM40 ( net664, Pbias, VDD, VDD );
gpdk090_pmos2v #(.ps(81.2u), .m(4 * 1), .as(24p), .l(500n), .pd(81.2u),
 .ad(24p), .w(40u)) (*
integer library_binding = "gpdk090";
integer
passed_mfactor = "m";
 *)
PM41 ( I_100u_Rpoly, Pcasc, net664, net664 );
gpdk090_pmos2v #(.ps(2.8u), .m(1 * 1), .as(460f), .l(280.0n), .pd(2.8u),
 .ad(460f), .w(500n)) (*
integer library_binding = "gpdk090";
integer
passed_mfactor = "m";
 *)
PM46 ( Pbias, siddq_c, VDD, VDD );
gpdk090_pmos2v #(.ps(2.8u), .m(1 * 1), .as(460f), .l(280.0n), .pd(2.8u),
 .ad(460f), .w(500n)) (*
integer library_binding = "gpdk090";
integer
passed_mfactor = "m";
 *)
PM47 ( Pcasc, siddq_c, VDD, VDD );
gpdk090_pmos2v #(.ps(81.2u), .m(4 * 1), .as(24p), .l(4u), .pd(81.2u),
.ad(24p), .w(40u)) (*
integer library_binding = "gpdk090";
integer
passed_mfactor = "m";
 *)
PM93 ( CASC_AC_OUT, Pbias, VDD, VDD );
gpdk090_pmos2v #(.ps(2.8u), .m(1 * 1), .as(476f), .l(280.0n), .pd(2.8u),
 .ad(476f), .w(580n)) (*
integer library_binding = "gpdk090";
integer
passed_mfactor = "m";
 *)
PM44 ( I_25u_Rpoly_PLL[1], siddq_c, VDD, VDD );
gpdk090_pmos2v #(.ps(2.8u), .m(1 * 1), .as(476f), .l(280.0n), .pd(2.8u),
 .ad(476f), .w(580n)) (*
integer library_binding = "gpdk090";
integer
passed_mfactor = "m";
 *)
PM45 ( I_25u_Rpoly_PLL[0], siddq_c, VDD, VDD );
gpdk090_pmos2v #(.ps(81.2u), .m(4 * 1), .as(24p), .l(500n), .pd(81.2u),
 .ad(24p), .w(40u)) (*
integer library_binding = "gpdk090";
integer
passed_mfactor = "m";
 *)
PM72 ( net599, Pcasc, CASC_AC_OUT,
CASC_AC_OUT );
gpdk090_pmos2v #(.ps(2.8u), .m(1 * 1), .as(460f), .l(280.0n), .pd(2.8u),
 .ad(460f), .w(500n)) (*
integer library_binding = "gpdk090";
integer
passed_mfactor = "m";
 *)
PM10 ( net687, siddq_c, VDD, VDD );
gpdk090_pmos2v #(.ps(21.2u), .m(1 * 1), .as(6p), .l(4u), .pd(21.2u), .ad(6p),
 .w(10u)) (*
integer library_binding = "gpdk090";
integer
passed_mfactor = "m";
 *)
PM11 ( net687, net687, VDD, VDD );
gpdk090_pmos2v #(.ps(21.2u), .m(1 * 1), .as(6p), .l(4u), .pd(21.2u), .ad(6p),
 .w(10u)) (*
integer library_binding = "gpdk090";
integer
passed_mfactor = "m";
 *)
PM12 ( Ib1, net687, VDD, VDD );
gpdk090_pmos2v #(.ps(21.2u), .m(4 * 1), .as(6p), .l(1u), .pd(21.2u), .ad(6p),
 .w(10u)) (*
integer library_binding = "gpdk090";
integer
passed_mfactor = "m";
 *)
PM32 ( Pcasc, CASC_AC_IN, VDD, VDD );
gpdk090_pmos2v #(.ps(81.2u), .m(4 * 1), .as(24p), .l(4u), .pd(81.2u),
.ad(24p), .w(40u)) (*
integer library_binding = "gpdk090";
integer
passed_mfactor = "m";
 *)
PM13 ( net716, net0167, VDD, VDD );

gpdk090_nmos2v #(.ps(3.52u), .m(1 * 1), .as(696f), .l(280.0n), .pd(3.52u),
 .ad(696f), .w(1.16u)) (*
integer library_binding = "gpdk090";

integer passed_mfactor = "m";
 *)
NM5 ( vss, vss, vss, vss );
gpdk090_nmos2v #(.ps(41.2u), .m(1 * 1), .as(12p), .l(6u), .pd(41.2u),
.ad(12p), .w(20u)) (*
integer library_binding = "gpdk090";
integer
passed_mfactor = "m";
 *)
NM60 ( net575, net543, vss, vss );
gpdk090_nmos2v #(.ps(41.2u), .m(3 * 1), .as(12p), .l(1u), .pd(41.2u),
.ad(12p), .w(20u)) (*
integer library_binding = "gpdk090";
integer
passed_mfactor = "m";
 *)
NM61 ( I_25u_Rpoly_PLL[0], net623, net575,
vss );
gpdk090_nmos2v #(.ps(3.52u), .m(1 * 1), .as(696f), .l(280.0n), .pd(3.52u),
 .ad(696f), .w(1.16u)) (*
integer library_binding = "gpdk090";

integer passed_mfactor = "m";
 *)
NM39 ( vss, vss, vss, vss );
gpdk090_nmos2v #(.ps(3.52u), .m(1 * 1), .as(696f), .l(280.0n), .pd(3.52u),
 .ad(696f), .w(1.16u)) (*
integer library_binding = "gpdk090";

integer passed_mfactor = "m";
 *)
NM40 ( net623, siddq, vss, vss );
gpdk090_nmos2v #(.ps(3.52u), .m(1 * 1), .as(696f), .l(280.0n), .pd(3.52u),
 .ad(696f), .w(1.16u)) (*
integer library_binding = "gpdk090";

integer passed_mfactor = "m";
 *)
NM41 ( net619, siddq, vss, vss );
gpdk090_nmos2v #(.ps(3.52u), .m(1 * 1), .as(696f), .l(280.0n), .pd(3.52u),
 .ad(696f), .w(1.16u)) (*
integer library_binding = "gpdk090";

integer passed_mfactor = "m";
 *)
NM42 ( I_100u_Rpoly, siddq, vss, vss );
gpdk090_nmos2v #(.ps(11.2u), .m(1 * 2), .as(3p), .l(6u), .pd(5.6u), .ad(1.5p),
 .w(5u)) (*
integer library_binding = "gpdk090";
integer
passed_mfactor = "m";
 *)
NM38 ( Pcasc, Ibias, vss, vss );
gpdk090_nmos2v #(.ps(21.2u), .m(1 * 1), .as(6p), .l(1u), .pd(21.2u), .ad(6p),
 .w(10u)) (*
integer library_binding = "gpdk090";
integer
passed_mfactor = "m";
 *)
NM55 ( net623, net623, net603, vss );
gpdk090_nmos2v #(.ps(41.2u), .m(12 * 1), .as(12p), .l(1u), .pd(41.2u),
 .ad(12p), .w(20u)) (*
integer library_binding = "gpdk090";
integer
passed_mfactor = "m";
 *)
NM8 ( net619, net623, net607, vss );
gpdk090_nmos2v #(.ps(21.2u), .m(1 * 1), .as(6p), .l(1u), .pd(21.2u), .ad(6p),
 .w(10u)) (*
integer library_binding = "gpdk090";
integer
passed_mfactor = "m";
 *)
NM53 ( net615, net623, vss, vss );
gpdk090_nmos2v #(.ps(2.8u), .m(1 * 1), .as(476f), .l(280.0n), .pd(2.8u),
 .ad(476f), .w(580n)) (*
integer library_binding = "gpdk090";
integer
passed_mfactor = "m";
 *)
NM66 ( net623, siddq, vss, vss );
gpdk090_nmos2v #(.ps(41.2u), .m(3 * 1), .as(12p), .l(1u), .pd(41.2u),
.ad(12p), .w(20u)) (*
integer library_binding = "gpdk090";
integer
passed_mfactor = "m";
 *)
NM62 ( I_25u_Rpoly_PLL[1], net623, net555,
vss );
gpdk090_nmos2v #(.ps(11.2u), .m(1 * 1), .as(3p), .l(1u), .pd(11.2u), .ad(3p),
 .w(5u)) (*
integer library_binding = "gpdk090";
integer
passed_mfactor = "m";
 *)
NM56 ( net599, net599, vss, vss );
gpdk090_nmos2v #(.ps(2.8u), .m(1 * 1), .as(476f), .l(280.0n), .pd(2.8u),
 .ad(476f), .w(580n)) (*
integer library_binding = "gpdk090";
integer
passed_mfactor = "m";
 *)
NM65 ( net543, siddq, vss, vss );
gpdk090_nmos2v #(.ps(30.9u), .m(1 * 4), .as(9p), .l(6u), .pd(20.6u), .ad(6p),
 .w(20u)) (*
integer library_binding = "gpdk090";
integer
passed_mfactor = "m";
 *)
NM50 ( net607, net619, vss, vss );
gpdk090_nmos2v #(.ps(21.2u), .m(1 * 1), .as(6p), .l(1u), .pd(21.2u), .ad(6p),
 .w(10u)) (*
integer library_binding = "gpdk090";
integer
passed_mfactor = "m";
 *)
NM54 ( net603, net623, net615, vss );
gpdk090_nmos2v #(.ps(41.2u), .m(1 * 1), .as(12p), .l(6u), .pd(41.2u),
.ad(12p), .w(20u)) (*
integer library_binding = "gpdk090";
integer
passed_mfactor = "m";
 *)
NM63 ( net555, net543, vss, vss );
gpdk090_nmos2v #(.ps(2.8u), .m(1 * 1), .as(476f), .l(280.0n), .pd(2.8u),
 .ad(476f), .w(580n)) (*
integer library_binding = "gpdk090";
integer
passed_mfactor = "m";
 *)
NM67 ( net599, siddq, vss, vss );
gpdk090_nmos2v #(.ps(2.8u), .m(1 * 1), .as(476f), .l(280.0n), .pd(2.8u),
 .ad(476f), .w(580n)) (*
integer library_binding = "gpdk090";
integer
passed_mfactor = "m";
 *)
NM9 ( Ib1, siddq, vss, vss );
gpdk090_nmos2v #(.ps(21.2u), .m(1 * 1), .as(6p), .l(1u), .pd(21.2u), .ad(6p),
 .w(10u)) (*
integer library_binding = "gpdk090";
integer
passed_mfactor = "m";
 *)
NM10 ( Ibias, siddq, vss, vss );
gpdk090_nmos2v #(.ps(11.2u), .m(2 * 1), .as(3p), .l(6u), .pd(11.2u), .ad(3p),
 .w(5u)) (*
integer library_binding = "gpdk090";
integer
passed_mfactor = "m";
 *)
NM11 ( Ibias, Ibias, vss, vss );
gpdk090_nmos2v #(.ps(11.2u), .m(2 * 1), .as(3p), .l(6u), .pd(11.2u), .ad(3p),
 .w(5u)) (*
integer library_binding = "gpdk090";
integer
passed_mfactor = "m";
 *)
NM12 ( net687, Ibias, vss, vss );

gpdk090_pmoscap2v #(.m(1 * 10), .l(2.935u), .w(2.755u)) (*
integer
library_binding = "gpdk090";
integer passed_mfactor = "m";
 *)
C2 (
VDD, Pcasc, VDD, VDD );
gpdk090_pmoscap2v #(.m(1 * 10), .l(4.155u), .w(3.905u)) (*
integer
library_binding = "gpdk090";
integer passed_mfactor = "m";
 *)
C4 (
VDD, Pbias, VDD, VDD );

gpdk090_nmoscap2v #(.m(10 * 1), .l(12.865u), .w(12.825u)) (*
integer
library_binding = "gpdk090";
integer passed_mfactor = "m";
 *)
C3 (
vss, net543, vss, vss );

inv_1x_hv (*
integer library_binding = "ether";
integer cds_net_set
[0:1] = { "DVSS","DVDD" };
integer DVSS = "vss";
integer DVDD
 = "VDD";
 *)
I19 ( .Y( siddq_c ), .A( siddq ) );

Bias_opamp_cascode_lowgain (*
integer library_binding = "ether";
 *)

I14 ( .inp( RPOLY_IN ), .vss( vss ), .VDD( VDD ), .siddq( siddq ), .inm(
Vref ), .ibias1( Ib1 ), .out( net0167 ) );

endmodule
