// Verilog-AMS netlist generated by the AMS netlister, version ICOA5.2.51.500.7.
// Cadence Design Systems, Inc.

`include "disciplines.vams"

module trans_ld_10bt_100tx_B ( BI_DAM,BASE100_DIS,MLT3ENC_DATA,gnd,vdd,
siddq,ibias_rext_400u,I_100u_Rext_NC,BASE10_TX_DIS,ibias_rext_50u,
BASE10_DIS,ibias_rext2_50u,dgnd,dvdd,TP_DIS,BI_DAP,tenbt_filter,
clk_160mhz,reset );

inout   BI_DAM;
input   BASE100_DIS;
input [1:0]  MLT3ENC_DATA;

input   gnd;
input   vdd;
input   siddq;
input   ibias_rext_400u;

input   I_100u_Rext_NC;
input   BASE10_TX_DIS;
input
 ibias_rext_50u;
input   BASE10_DIS;
input   ibias_rext2_50u;
input
 dgnd;
input   dvdd;
input   TP_DIS;
inout   BI_DAP;
input [4:0]
 tenbt_filter;
input   clk_160mhz;
input   reset;

parameter iout10BT=0;
parameter iout100TX=0;
parameter ibias100TX=0;
parameter ibias10BT=0;

gpdk090_nmoscap2v #(.m(1 * 100), .l(12.87u), .w(24.615u)) (*
integer
library_binding = "gpdk090";
integer passed_mfactor = "m";
 *)
C0 (
gnd, vdd, gnd, gnd );
gpdk090_nmoscap2v #(.m(1 * 37), .l(8u), .w(20.62u)) (*
integer
library_binding = "gpdk090";
integer passed_mfactor = "m";
 *)
C1 (
gnd, vdd, gnd, gnd );

trans_ld_tenbt (*
integer library_binding = "ether";
 *)
I40 ( .avdd(
vdd ), .ibias_tenbt( net104 ), .dvdd( dvdd ), .ibias_rext2_50u(
ibias_rext2_50u ), .gnd( gnd ), .neg_out( BI_DAM ), .tenbt_on(
tenbt_on ), .pos_out( BI_DAP ), .dgnd( dgnd ), .siddq( siddq ), .tenbt_trans_off(
BASE10_TX_DIS ), .MAN_ENC( clk_160mhz ), .ibias_tenbt_cas( net110 ) );

or2_2x_hv (*
integer library_binding = "ether";
integer cds_net_set
[0:1] = { "DVSS","DVDD" };
integer DVSS = "gnd";
integer DVDD
 = "vdd";
 *)
I43 ( .Y( net132 ), .B( TP_DIS ), .A( siddq ) );

and2_1x_hv (*
integer library_binding = "ether";
integer cds_net_set
[0:1] = { "DVDD","DVSS" };
integer DVDD = "vdd";
integer DVSS
 = "gnd";
 *)
I42 ( .Y( tx_on ), .B( BASE10_DIS ), .A( net124 ) );

inv_1x_hv (*
integer library_binding = "ether";
integer cds_net_set
[0:1] = { "DVSS","DVDD" };
integer DVSS = "gnd";
integer DVDD
 = "vdd";
 *)
I36 ( .Y( net124 ), .A( BASE100_DIS ) );

inv_4x_hv (*
integer library_binding = "ether";
integer cds_net_set
[0:1] = { "DVDD","DVSS" };
integer DVDD = "vdd";
integer DVSS
 = "gnd";
 *)
I33 ( .Y( tenbt_on ), .A( BASE10_DIS ) );

trans_ld_bias_mux (*
integer library_binding = "ether";
 *)
I30 ( .ibias_100tx_100u(
net109 ), .ibias_tenbt( net104 ), .dvdd( vdd ), .ibias_rext_100u(
I_100u_Rext_NC ), .tenbt_on( tenbt_on ), .dgnd( gnd ), .siddq( net132 ),
.ibias_100tx( net105 ), .ibias_rext_400u( ibias_rext_400u ), .tx_on(
tx_on ), .ibias_tenbt_cas( net110 ) );

trans_ld_100tx (*
integer library_binding = "ether";
 *)
I41 ( .ibias_rext_50u(
ibias_rext_50u ), .ibias_100tx_100u( net109 ), .ibias_100tx_400u(
net105 ), .neg_out( BI_DAM ), .VDD( vdd ), .pos_out( BI_DAP ), .siddq(
siddq ), .VSS( gnd ), .TX_on( tx_on ), .MLT3ENC_DATA(
MLT3ENC_DATA[1:0] ) );

endmodule
