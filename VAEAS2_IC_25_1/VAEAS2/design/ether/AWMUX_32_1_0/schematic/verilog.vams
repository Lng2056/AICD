// Verilog-AMS netlist generated by the AMS netlister, version ICOA5.2.51.500.7.
// Cadence Design Systems, Inc.

`include "disciplines.vams"

module AWMUX_32_1_0 ( O0,I0,I1,I2,I3,I4,I5,I6,I7,I8,I9,I10,I11,I12,I13,
I14,I15,I16,I17,I18,I19,I20,I21,I22,I23,I24,I25,I26,I27,I28,I29,I30,
I31,S );

output   O0;
input   I0;
input   I1;
input   I2;
input   I3;
input
 I4;
input   I5;
input   I6;
input   I7;
input   I8;
input   I9;

input   I10;
input   I11;
input   I12;
input   I13;
input   I14;

input   I15;
input   I16;
input   I17;
input   I18;
input   I19;

input   I20;
input   I21;
input   I22;
input   I23;
input   I24;

input   I25;
input   I26;
input   I27;
input   I28;
input   I29;

input   I30;
input   I31;
input [4:0]  S;

wire I28;
wire I19;
wire I20;
wire O0;
wire I8;
wire I11;
wire I30;
wire I14;
wire I21;
wire n_260;
wire n_271;
wire I9;
wire I22;
wire n_258;
wire I3;
wire I18;
wire I10;
wire I0;
wire I12;
wire [4:0] S;
wire n_16;
wire I16;
wire I27;
wire n_6;
wire n_13;
wire n_25371;
wire I2;
wire I7;
wire n_266;
wire n_27189;
wire I17;
wire I29;
wire I1;
wire n_23964;
wire I24;
wire n_273;
wire n_234;
wire I31;
wire n_23459;
wire n_21;
wire I13;
wire n_26684;
wire I23;
wire I26;
wire n_253;
wire n_239;
wire I5;
wire I4;
wire I25;
wire n_25876;
wire n_27391;
wire n_15;
wire I15;
wire n_18;
wire n_26078;
wire I6;

MX2X1 (*
integer library_binding = "gsclib090";
 *)
i_12190 ( .Y(
n_25371 ), .S0( S[2] ), .B( I12 ), .A( I8 ) );
MX2X1 (*
integer library_binding = "gsclib090";
 *)
i_143 ( .Y( n_6 ),
.S0( S[0] ), .B( n_273 ), .A( n_260 ) );
MX2X1 (*
integer library_binding = "gsclib090";
 *)
i_141 ( .Y( n_273 ),
.S0( S[1] ), .B( n_271 ), .A( n_266 ) );
MX2X1 (*
integer library_binding = "gsclib090";
 *)
i_139 ( .Y( n_271 ),
.S0( S[2] ), .B( I7 ), .A( I3 ) );
MX2X1 (*
integer library_binding = "gsclib090";
 *)
i_134 ( .Y( n_266 ),
.S0( S[2] ), .B( I5 ), .A( I1 ) );
MX2X1 (*
integer library_binding = "gsclib090";
 *)
i_12695 ( .Y(
n_25876 ), .S0( S[2] ), .B( I14 ), .A( I10 ) );
MX2X1 (*
integer library_binding = "gsclib090";
 *)
i_128 ( .Y( n_260 ),
.S0( S[1] ), .B( n_258 ), .A( n_253 ) );
MX2X1 (*
integer library_binding = "gsclib090";
 *)
i_126 ( .Y( n_258 ),
.S0( S[2] ), .B( I6 ), .A( I2 ) );
MX2X1 (*
integer library_binding = "gsclib090";
 *)
i_12897 ( .Y(
n_26078 ), .S0( S[1] ), .B( n_25876 ), .A( n_25371 ) );
MX2X1 (*
integer library_binding = "gsclib090";
 *)
i_121 ( .Y( n_253 ),
.S0( S[2] ), .B( I4 ), .A( I0 ) );
MX2X1 (*
integer library_binding = "gsclib090";
 *)
i_11584 ( .Y( n_21 ),
.S0( S[1] ), .B( n_23964 ), .A( n_23459 ) );
MX2X1 (*
integer library_binding = "gsclib090";
 *)
i_11382 ( .Y(
n_23964 ), .S0( S[2] ), .B( I0 ), .A( n_16 ) );
MX2X1 (*
integer library_binding = "gsclib090";
 *)
i_134103 ( .Y(
n_26684 ), .S0( S[2] ), .B( I13 ), .A( I9 ) );
MX2X1 (*
integer library_binding = "gsclib090";
 *)
i_10877 ( .Y(
n_23459 ), .S0( S[2] ), .B( n_18 ), .A( n_15 ) );
MX2X1 (*
integer library_binding = "gsclib090";
 *)
i_115 ( .Y( O0 ),
.S0( S[3] ), .B( n_239 ), .A( n_234 ) );
MX2X1 (*
integer library_binding = "gsclib090";
 *)
i_113 ( .Y( n_239 ),
.S0( S[4] ), .B( I0 ), .A( n_13 ) );
MX2X1 (*
integer library_binding = "gsclib090";
 *)
i_108 ( .Y( n_234 ),
.S0( S[4] ), .B( n_21 ), .A( n_6 ) );
MX2X1 (*
integer library_binding = "gsclib090";
 *)
i_139108 ( .Y(
n_27189 ), .S0( S[2] ), .B( I15 ), .A( I11 ) );
MX2X1 (*
integer library_binding = "gsclib090";
 *)
i_15 ( .Y( n_15 ),
.S0( S[0] ), .B( I17 ), .A( I16 ) );
MX2X1 (*
integer library_binding = "gsclib090";
 *)
i_141110 ( .Y(
n_27391 ), .S0( S[1] ), .B( n_27189 ), .A( n_26684 ) );
MX2X1 (*
integer library_binding = "gsclib090";
 *)
i_16 ( .Y( n_16 ),
.S0( S[0] ), .B( I19 ), .A( I18 ) );
MX2X1 (*
integer library_binding = "gsclib090";
 *)
i_18 ( .Y( n_18 ),
.S0( S[0] ), .B( I21 ), .A( I20 ) );
MX2X1 (*
integer library_binding = "gsclib090";
 *)
i_143112 ( .Y(
n_13 ), .S0( S[0] ), .B( n_27391 ), .A( n_26078 ) );

endmodule
