// Verilog-AMS netlist generated by the AMS netlister, version ICOA5.2.51.500.7.
// Cadence Design Systems, Inc.

`include "disciplines.vams"

module Bias_opamp_cascode_lowgain ( inp,vss,VDD,siddq,inm,ibias1,out );

input   inp;
input   vss;
input   VDD;
input   siddq;
input   inm;

input   ibias1;
output   out;

gpdk090_nmos2v #(.ps(45.9u), .m(2 * 4), .as(13.5p), .l(350.0n), .pd(30.6u),
 .ad(9p), .w(30u)) (*
integer library_binding = "gpdk090";
integer
passed_mfactor = "m";
 *)
NM4 ( net55, inp, net0113, vss );
gpdk090_nmos2v #(.ps(11.2u), .m(2 * 1), .as(3p), .l(15.0u), .pd(11.2u),
 .ad(3p), .w(5u)) (*
integer library_binding = "gpdk090";
integer
passed_mfactor = "m";
 *)
M8 ( net230, net230, vss, vss );
gpdk090_nmos2v #(.ps(13.2u), .m(1 * 1), .as(3.6p), .l(4u), .pd(13.2u),
 .ad(3.6p), .w(6u)) (*
integer library_binding = "gpdk090";
integer
passed_mfactor = "m";
 *)
M1 ( ibias1, ibias1, vss, vss );
gpdk090_nmos2v #(.ps(45.9u), .m(2 * 4), .as(13.5p), .l(350.0n), .pd(30.6u),
 .ad(9p), .w(30u)) (*
integer library_binding = "gpdk090";
integer
passed_mfactor = "m";
 *)
NM5 ( net59, inm, net0113, vss );
gpdk090_nmos2v #(.ps(9.2u), .m(1 * 1), .as(2.4p), .l(4u), .pd(9.2u), .ad(2.4p),
 .w(4u)) (*
integer library_binding = "gpdk090";
integer
passed_mfactor = "m";
 *)
NM1 ( vss, vss, vss, vss );
gpdk090_nmos2v #(.ps(9.2u), .m(1 * 1), .as(2.4p), .l(4u), .pd(9.2u), .ad(2.4p),
 .w(4u)) (*
integer library_binding = "gpdk090";
integer
passed_mfactor = "m";
 *)
NM3 ( vss, vss, vss, vss );
gpdk090_nmos2v #(.ps(2.8u), .m(1 * 1), .as(476f), .l(280.0n), .pd(2.8u),
 .ad(476f), .w(580n)) (*
integer library_binding = "gpdk090";
integer
passed_mfactor = "m";
 *)
NM8 ( net230, siddq, vss, vss );
gpdk090_nmos2v #(.ps(2.8u), .m(1 * 1), .as(476f), .l(280.0n), .pd(2.8u),
 .ad(476f), .w(580n)) (*
integer library_binding = "gpdk090";
integer
passed_mfactor = "m";
 *)
NM0 ( net0113, siddq, vss, vss );
gpdk090_nmos2v #(.ps(2.8u), .m(1 * 1), .as(476f), .l(280.0n), .pd(2.8u),
 .ad(476f), .w(580n)) (*
integer library_binding = "gpdk090";
integer
passed_mfactor = "m";
 *)
NM2 ( net230, siddq, vss, vss );
gpdk090_nmos2v #(.ps(13.2u), .m(1 * 1), .as(3.6p), .l(4u), .pd(13.2u),
 .ad(3.6p), .w(6u)) (*
integer library_binding = "gpdk090";
integer
passed_mfactor = "m";
 *)
M14 ( net33, ibias1, vss, vss );
gpdk090_nmos2v #(.ps(13.2u), .m(1 * 1), .as(3.6p), .l(4u), .pd(13.2u),
 .ad(3.6p), .w(6u)) (*
integer library_binding = "gpdk090";
integer
passed_mfactor = "m";
 *)
M11 ( net0113, ibias1, vss, vss );
gpdk090_nmos2v #(.ps(13.2u), .m(1 * 1), .as(3.6p), .l(4u), .pd(13.2u),
 .ad(3.6p), .w(6u)) (*
integer library_binding = "gpdk090";
integer
passed_mfactor = "m";
 *)
M10 ( net180, ibias1, vss, vss );
gpdk090_nmos2v #(.ps(11.2u), .m(2 * 1), .as(3p), .l(15.0u), .pd(11.2u),
 .ad(3p), .w(5u)) (*
integer library_binding = "gpdk090";
integer
passed_mfactor = "m";
 *)
M9 ( out, net230, vss, vss );

gpdk090_pmos2v #(.ps(24.52u), .m(2 * 2), .as(6.996p), .l(280.0n), .pd(12.26u),
 .ad(3.498p), .w(11.66u)) (*
integer library_binding = "gpdk090";

integer passed_mfactor = "m";
 *)
M7 ( out, net33, net59, VDD );
gpdk090_pmos2v #(.ps(24.52u), .m(2 * 2), .as(6.996p), .l(280.0n), .pd(12.26u),
 .ad(3.498p), .w(11.66u)) (*
integer library_binding = "gpdk090";

integer passed_mfactor = "m";
 *)
M6 ( net230, net33, net55, VDD );
gpdk090_pmos2v #(.ps(25.2u), .m(1 * 2), .as(7.2p), .l(4u), .pd(12.6u),
 .ad(3.6p), .w(12u)) (*
integer library_binding = "gpdk090";
integer
passed_mfactor = "m";
 *)
M5 ( net59, net180, VDD, VDD );
gpdk090_pmos2v #(.ps(25.2u), .m(1 * 2), .as(7.2p), .l(4u), .pd(12.6u),
 .ad(3.6p), .w(12u)) (*
integer library_binding = "gpdk090";
integer
passed_mfactor = "m";
 *)
M4 ( net55, net180, VDD, VDD );
gpdk090_pmos2v #(.ps(2.8u), .m(1 * 1), .as(476f), .l(280.0n), .pd(2.8u),
 .ad(476f), .w(580n)) (*
integer library_binding = "gpdk090";
integer
passed_mfactor = "m";
 *)
PM1 ( net180, siddq_n, VDD, VDD );
gpdk090_pmos2v #(.ps(2.8u), .m(1 * 1), .as(476f), .l(280.0n), .pd(2.8u),
 .ad(476f), .w(580n)) (*
integer library_binding = "gpdk090";
integer
passed_mfactor = "m";
 *)
PM4 ( net33, siddq_n, VDD, VDD );
gpdk090_pmos2v #(.ps(13.2u), .m(1 * 1), .as(3.6p), .l(4u), .pd(13.2u),
 .ad(3.6p), .w(6u)) (*
integer library_binding = "gpdk090";
integer
passed_mfactor = "m";
 *)
M13 ( net33, net33, VDD, VDD );
gpdk090_pmos2v #(.ps(25.2u), .m(1 * 2), .as(7.2p), .l(4u), .pd(12.6u),
 .ad(3.6p), .w(12u)) (*
integer library_binding = "gpdk090";
integer
passed_mfactor = "m";
 *)
M12 ( net180, net180, VDD, VDD );

inv_1X (*
integer library_binding = "ether";
 *)
I2 ( .vss( vss ), .VDD(
VDD ), .in( siddq ), .out( siddq_n ) );

endmodule
