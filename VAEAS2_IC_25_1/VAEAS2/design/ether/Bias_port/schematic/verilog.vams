// Verilog-AMS netlist generated by the AMS netlister, version ICOA5.2.51.500.7.
// Cadence Design Systems, Inc.

`include "disciplines.vams"

module Bias_port ( I_REXT_REF100,SIDDQ,I_RPOLY_100,I_REXT_100,
I_REXT_50,VDD,VSS,I_RPOLY_REF100,I_REXT_100_NC );

input   I_REXT_REF100;
input   SIDDQ;
output [5:0]  I_RPOLY_100;

output [6:0]  I_REXT_100;
output [1:0]  I_REXT_50;
input   VDD;

input   VSS;
input   I_RPOLY_REF100;
output   I_REXT_100_NC;

wire [9:0] I_RPOLY_100_netclash;
wire [1:0] I_REXT_400;
wire [8:0] I_REXT_100_netclash;
wire [2:0] I_REXT_50_netclash;

cds_alias #(.width(6)) (*
integer library_binding = "basic";
integer
view_binding = "functional";
 *)
ams_alias_inst_0 (I_RPOLY_100[5:0],
I_RPOLY_100_netclash[5:0]);
cds_alias #(.width(7)) (*
integer library_binding = "basic";
integer
view_binding = "functional";
 *)
ams_alias_inst_1 (I_REXT_100[6:0],
I_REXT_100_netclash[6:0]);
cds_alias #(.width(2)) (*
integer library_binding = "basic";
integer
view_binding = "functional";
 *)
ams_alias_inst_2 (I_REXT_50[1:0],
I_REXT_50_netclash[1:0]);

gpdk090_resnsppoly #(.w(2u), .r(50.0014K), .l(250.003u)) (*
integer
library_binding = "gpdk090";
 *)
R1 ( net270, net118, VSS );
gpdk090_resnsppoly #(.w(2u), .r(50.0014K), .l(250.003u)) (*
integer
library_binding = "gpdk090";
 *)
R2 ( net273, net154, VSS );

gpdk090_nmos2v #(.ps(30.9u), .m(1 * 4), .as(9p), .l(2.5u), .pd(20.6u),
 .ad(6p), .w(20u)) (*
integer library_binding = "gpdk090";
integer
passed_mfactor = "m";
 *)
NM10 ( net118, net118, VSS, VSS );
gpdk090_nmos2v #(.ps(25.75u), .m(1 * 8), .as(7.5p), .l(2.5u), .pd(20.6u),
 .ad(6p), .w(20u)) (*
integer library_binding = "gpdk090";
integer
passed_mfactor = "m";
 *)
NM3 ( net124, net124, VSS, VSS );
gpdk090_nmos2v #(.ps(13.25u), .m(1 * 8), .as(3.75p), .l(500n), .pd(10.6u),
 .ad(3p), .w(10u)) (*
integer library_binding = "gpdk090";
integer
passed_mfactor = "m";
 *)
NM45 ( net140, net140, net172, VSS );
gpdk090_nmos2v #(.ps(3.53u), .m(1 * 1), .as(699f), .l(280.0n), .pd(3.53u),
 .ad(699f), .w(1.165u)) (*
integer library_binding = "gpdk090";

integer passed_mfactor = "m";
 *)
NM7 ( net273, siddq, VSS, VSS );
gpdk090_nmos2v #(.ps(30.9u), .m(1 * 4), .as(9p), .l(2.5u), .pd(20.6u),
 .ad(6p), .w(20u)) (*
integer library_binding = "gpdk090";
integer
passed_mfactor = "m";
 *)
NM4 ( Pcasc2, net273, VSS, VSS );
gpdk090_nmos2v #(.ps(21.2u), .m(1 * 1), .as(6p), .l(500n), .pd(21.2u),
 .ad(6p), .w(10u)) (*
integer library_binding = "gpdk090";
integer
passed_mfactor = "m";
 *)
NM44 ( Pbias1, net140, net162, VSS );
gpdk090_nmos2v #(.ps(13.25u), .m(1 * 8), .as(3.75p), .l(500n), .pd(10.6u),
 .ad(3p), .w(10u)) (*
integer library_binding = "gpdk090";
integer
passed_mfactor = "m";
 *)
NM8 ( net160, net160, net124, VSS );
gpdk090_nmos2v #(.ps(3.53u), .m(1 * 1), .as(699f), .l(280.0n), .pd(3.53u),
 .ad(699f), .w(1.165u)) (*
integer library_binding = "gpdk090";

integer passed_mfactor = "m";
 *)
NM43 ( net270, siddq, VSS, VSS );
gpdk090_nmos2v #(.ps(30.9u), .m(1 * 4), .as(9p), .l(2.5u), .pd(20.6u),
 .ad(6p), .w(20u)) (*
integer library_binding = "gpdk090";
integer
passed_mfactor = "m";
 *)
NM5 ( net150, net273, VSS, VSS );
gpdk090_nmos2v #(.ps(30.9u), .m(1 * 4), .as(9p), .l(2.5u), .pd(20.6u),
 .ad(6p), .w(20u)) (*
integer library_binding = "gpdk090";
integer
passed_mfactor = "m";
 *)
NM6 ( net154, net154, VSS, VSS );
gpdk090_nmos2v #(.ps(21.2u), .m(1 * 1), .as(6p), .l(500n), .pd(21.2u),
 .ad(6p), .w(10u)) (*
integer library_binding = "gpdk090";
integer
passed_mfactor = "m";
 *)
NM9 ( Pbias2, net160, net150, VSS );
gpdk090_nmos2v #(.ps(30.9u), .m(1 * 4), .as(9p), .l(2.5u), .pd(20.6u),
 .ad(6p), .w(20u)) (*
integer library_binding = "gpdk090";
integer
passed_mfactor = "m";
 *)
NM0 ( net162, net270, VSS, VSS );
gpdk090_nmos2v #(.ps(30.9u), .m(1 * 4), .as(9p), .l(2.5u), .pd(20.6u),
 .ad(6p), .w(20u)) (*
integer library_binding = "gpdk090";
integer
passed_mfactor = "m";
 *)
NM1 ( Pcasc1, net270, VSS, VSS );
gpdk090_nmos2v #(.ps(25.75u), .m(1 * 8), .as(7.5p), .l(2.5u), .pd(20.6u),
 .ad(6p), .w(20u)) (*
integer library_binding = "gpdk090";
integer
passed_mfactor = "m";
 *)
NM2 ( net172, net172, VSS, VSS );
gpdk090_nmos2v #(.ps(3.53u), .m(1 * 1), .as(699f), .l(280.0n), .pd(3.53u),
 .ad(699f), .w(1.165u)) (*
integer library_binding = "gpdk090";

integer passed_mfactor = "m";
 *)
NM12 ( I_REXT_100_NC, siddq, VSS,
VSS );

gpdk090_pmos2v #(.ps(30.9u), .m(2 * 4), .as(9p), .l(2.5u), .pd(20.6u),
 .ad(6p), .w(20u)) (*
integer library_binding = "gpdk090";
integer
passed_mfactor = "m";
 *)
PM2 ( net205, Pbias1, VDD, VDD );
gpdk090_pmos2v #(.ps(12.72u), .m(1 * 10), .as(3.6p), .l(800n), .pd(10.6u),
 .ad(3p), .w(10u)) (*
integer library_binding = "gpdk090";
integer
passed_mfactor = "m";
 *)
PM3 ( Pbias2, Pcasc2, net185, VDD );
gpdk090_pmos2v #(.ps(21.2u), .m(1 * 1), .as(6p), .l(1u), .pd(21.2u), .ad(6p),
 .w(10u)) (*
integer library_binding = "gpdk090";
integer
passed_mfactor = "m";
 *)
PM77 ( net140, Pcasc1, VDD, VDD );
gpdk090_pmos2v #(.ps(21.2u), .m(1 * 1), .as(6p), .l(1u), .pd(21.2u), .ad(6p),
 .w(10u)) (*
integer library_binding = "gpdk090";
integer
passed_mfactor = "m";
 *)
PM4 ( Pcasc2, Pcasc2, VDD, VDD );
gpdk090_pmos2v #(.ps(21.2u), .m(1 * 1), .as(6p), .l(1u), .pd(21.2u), .ad(6p),
 .w(10u)) (*
integer library_binding = "gpdk090";
integer
passed_mfactor = "m";
 *)
PM1 ( net160, Pcasc2, VDD, VDD );
gpdk090_pmos2v #(.ps(3.53u), .m(1 * 1), .as(699f), .l(280.0n), .pd(3.53u),
 .ad(699f), .w(1.165u)) (*
integer library_binding = "gpdk090";

integer passed_mfactor = "m";
 *)
PM76 ( Pcasc2, siddq_c, VDD, VDD );
gpdk090_pmos2v #(.ps(12.72u), .m(1 * 10), .as(3.6p), .l(800n), .pd(10.6u),
 .ad(3p), .w(10u)) (*
integer library_binding = "gpdk090";
integer
passed_mfactor = "m";
 *)
PM71 ( Pbias1, Pcasc1, net205, VDD );
gpdk090_pmos2v #(.ps(3.53u), .m(1 * 1), .as(699f), .l(280.0n), .pd(3.53u),
 .ad(699f), .w(1.165u)) (*
integer library_binding = "gpdk090";

integer passed_mfactor = "m";
 *)
PM75 ( Pcasc1, siddq_c, VDD, VDD );
gpdk090_pmos2v #(.ps(3.53u), .m(1 * 1), .as(699f), .l(280.0n), .pd(3.53u),
 .ad(699f), .w(1.165u)) (*
integer library_binding = "gpdk090";

integer passed_mfactor = "m";
 *)
PM197 ( Pbias1, siddq_c, VDD, VDD );
gpdk090_pmos2v #(.ps(44.6475u), .m(1 * 4), .as(13.1242p), .l(280.0n),
.pd(29.765u), .ad(8.7495p), .w(29.165u)) (*
integer library_binding
 = "gpdk090";
integer passed_mfactor = "m";
 *)
PM49 ( net118, siddq,
I_REXT_REF100, VDD );
gpdk090_pmos2v #(.ps(21.2u), .m(1 * 1), .as(6p), .l(1u), .pd(21.2u), .ad(6p),
 .w(10u)) (*
integer library_binding = "gpdk090";
integer
passed_mfactor = "m";
 *)
PM33 ( Pcasc1, Pcasc1, VDD, VDD );
gpdk090_pmos2v #(.ps(44.6475u), .m(1 * 4), .as(13.1242p), .l(280.0n),
.pd(29.765u), .ad(8.7495p), .w(29.165u)) (*
integer library_binding
 = "gpdk090";
integer passed_mfactor = "m";
 *)
PM35 ( net154, siddq,
I_RPOLY_REF100, VDD );
gpdk090_pmos2v #(.ps(3.53u), .m(1 * 1), .as(699f), .l(280.0n), .pd(3.53u),
 .ad(699f), .w(1.165u)) (*
integer library_binding = "gpdk090";

integer passed_mfactor = "m";
 *)
PM34 ( Pbias2, siddq_c, VDD, VDD );
gpdk090_pmos2v #(.ps(30.9u), .m(2 * 4), .as(9p), .l(2.5u), .pd(20.6u),
 .ad(6p), .w(20u)) (*
integer library_binding = "gpdk090";
integer
passed_mfactor = "m";
 *)
PM0 ( net185, Pbias2, VDD, VDD );
gpdk090_pmos2v #(.ps(30.9u), .m(2 * 4), .as(9p), .l(2.5u), .pd(20.6u),
 .ad(6p), .w(20u)) (*
integer library_binding = "gpdk090";
integer
passed_mfactor = "m";
 *)
PM22 ( I_REXT_100_NC, Pbias1, VDD, VDD );

gpdk090_nmoscap2v #(.m(1 * 2), .l(20u), .w(20.64u)) (*
integer
library_binding = "gpdk090";
integer passed_mfactor = "m";
 *)
C2 (
VSS, VDD, VSS, VSS );
gpdk090_nmoscap2v #(.m(1 * 2), .l(20u), .w(20.64u)) (*
integer
library_binding = "gpdk090";
integer passed_mfactor = "m";
 *)
C3 (
VSS, VDD, VSS, VSS );
gpdk090_nmoscap2v #(.m(1 * 2), .l(20u), .w(20.64u)) (*
integer
library_binding = "gpdk090";
integer passed_mfactor = "m";
 *)
C5 (
VSS, VDD, VSS, VSS );
gpdk090_nmoscap2v #(.m(1 * 2), .l(20u), .w(20.64u)) (*
integer
library_binding = "gpdk090";
integer passed_mfactor = "m";
 *)
C4 (
VSS, VDD, VSS, VSS );
gpdk090_nmoscap2v #(.m(4 * 1), .l(12.865u), .w(12.825u)) (*
integer
library_binding = "gpdk090";
integer passed_mfactor = "m";
 *)
C1 (
VSS, net273, VSS, VSS );
gpdk090_nmoscap2v #(.m(4 * 1), .l(12.865u), .w(12.825u)) (*
integer
library_binding = "gpdk090";
integer passed_mfactor = "m";
 *)
C0 (
VSS, net270, VSS, VSS );

gpdk090_pmoscap2v #(.m(10 * 1), .l(13.15u), .w(12.33u)) (*
integer
library_binding = "gpdk090";
integer passed_mfactor = "m";
 *)
C10 (
VDD, Pcasc2, VDD, VDD );
gpdk090_pmoscap2v #(.m(10 * 1), .l(13.15u), .w(12.33u)) (*
integer
library_binding = "gpdk090";
integer passed_mfactor = "m";
 *)
C7 (
VDD, Pcasc1, VDD, VDD );
gpdk090_pmoscap2v #(.m(9 * 1), .l(13.15u), .w(12.33u)) (*
integer
library_binding = "gpdk090";
integer passed_mfactor = "m";
 *)
C11 (
VDD, Pbias1, VDD, VDD );
gpdk090_pmoscap2v #(.m(10 * 1), .l(13.15u), .w(12.33u)) (*
integer
library_binding = "gpdk090";
integer passed_mfactor = "m";
 *)
C12 (
VDD, Pbias2, VDD, VDD );

Bias_I_100u_Rpoly_cell_port (*
integer library_binding = "ether";

integer elaboration_binding = "P100[9:0]";
 *)
P100_9 ( .SIDDQ( siddq ),
.Iout( I_RPOLY_100_netclash[9] ), .Pcasc( Pcasc2 ), .VDD( VDD ), .Pbias(
Pbias2 ), .VSS( VSS ) ),
  P100_8 ( .SIDDQ( siddq ), .Iout( I_RPOLY_100_netclash[8] ), .Pcasc(
Pcasc2 ), .VDD( VDD ), .Pbias( Pbias2 ), .VSS( VSS ) ),
  P100_7 ( .SIDDQ( siddq ), .Iout( I_RPOLY_100_netclash[7] ), .Pcasc(
Pcasc2 ), .VDD( VDD ), .Pbias( Pbias2 ), .VSS( VSS ) ),
  P100_6 ( .SIDDQ( siddq ), .Iout( I_RPOLY_100_netclash[6] ), .Pcasc(
Pcasc2 ), .VDD( VDD ), .Pbias( Pbias2 ), .VSS( VSS ) ),
  P100_5 ( .SIDDQ( siddq ), .Iout( I_RPOLY_100_netclash[5] ), .Pcasc(
Pcasc2 ), .VDD( VDD ), .Pbias( Pbias2 ), .VSS( VSS ) ),
  P100_4 ( .SIDDQ( siddq ), .Iout( I_RPOLY_100_netclash[4] ), .Pcasc(
Pcasc2 ), .VDD( VDD ), .Pbias( Pbias2 ), .VSS( VSS ) ),
  P100_3 ( .SIDDQ( siddq ), .Iout( I_RPOLY_100_netclash[3] ), .Pcasc(
Pcasc2 ), .VDD( VDD ), .Pbias( Pbias2 ), .VSS( VSS ) ),
  P100_2 ( .SIDDQ( siddq ), .Iout( I_RPOLY_100_netclash[2] ), .Pcasc(
Pcasc2 ), .VDD( VDD ), .Pbias( Pbias2 ), .VSS( VSS ) ),
  P100_1 ( .SIDDQ( siddq ), .Iout( I_RPOLY_100_netclash[1] ), .Pcasc(
Pcasc2 ), .VDD( VDD ), .Pbias( Pbias2 ), .VSS( VSS ) ),
  P100_0 ( .SIDDQ( siddq ), .Iout( I_RPOLY_100_netclash[0] ), .Pcasc(
Pcasc2 ), .VDD( VDD ), .Pbias( Pbias2 ), .VSS( VSS ) );

inv_4x_hv (*
integer library_binding = "ether";
integer cds_net_set
[0:1] = { "DVDD","DVSS" };
integer DVDD = "VDD";
integer DVSS
 = "VSS";
 *)
I0 ( .Y( siddq_c ), .A( siddq ) );

clkbuf_4x_hv (*
integer library_binding = "ether";
integer cds_net_set
[0:1] = { "DVSS","DVDD" };
integer DVSS = "VSS";
integer DVDD
 = "VDD";
 *)
I2 ( .Y( siddq ), .A( SIDDQ ) );

Bias_I_400u_Rext_cell_port (*
integer library_binding = "ether";

integer elaboration_binding = "I4[1:0]";
 *)
I4_1 ( .SIDDQ( siddq ), .Iout(
I_REXT_400[1] ), .Pcasc( Pcasc1 ), .VDD( VDD ), .Pbias( Pbias1 ), .VSS(
VSS ) ),
  I4_0 ( .SIDDQ( siddq ), .Iout( I_REXT_400[0] ), .Pcasc( Pcasc1 ), .VDD(
VDD ), .Pbias( Pbias1 ), .VSS( VSS ) );

Bias_I_50u_Rext_cell_port (*
integer library_binding = "ether";

integer elaboration_binding = "I3[2:0]";
 *)
I3_2 ( .SIDDQ( siddq ), .Iout(
I_REXT_50_netclash[2] ), .Pcasc( Pcasc1 ), .VDD( VDD ), .Pbias( Pbias1 ),
.VSS( VSS ) ),
  I3_1 ( .SIDDQ( siddq ), .Iout( I_REXT_50_netclash[1] ), .Pcasc(
Pcasc1 ), .VDD( VDD ), .Pbias( Pbias1 ), .VSS( VSS ) ),
  I3_0 ( .SIDDQ( siddq ), .Iout( I_REXT_50_netclash[0] ), .Pcasc(
Pcasc1 ), .VDD( VDD ), .Pbias( Pbias1 ), .VSS( VSS ) );

Bias_I_100u_Rext_cell_port (*
integer library_binding = "ether";

integer elaboration_binding = "E100[8:0]";
 *)
E100_8 ( .SIDDQ( siddq ),
.Iout( I_REXT_100_netclash[8] ), .Pcasc( Pcasc1 ), .VDD( VDD ), .Pbias(
Pbias1 ), .VSS( VSS ) ),
  E100_7 ( .SIDDQ( siddq ), .Iout( I_REXT_100_netclash[7] ), .Pcasc(
Pcasc1 ), .VDD( VDD ), .Pbias( Pbias1 ), .VSS( VSS ) ),
  E100_6 ( .SIDDQ( siddq ), .Iout( I_REXT_100_netclash[6] ), .Pcasc(
Pcasc1 ), .VDD( VDD ), .Pbias( Pbias1 ), .VSS( VSS ) ),
  E100_5 ( .SIDDQ( siddq ), .Iout( I_REXT_100_netclash[5] ), .Pcasc(
Pcasc1 ), .VDD( VDD ), .Pbias( Pbias1 ), .VSS( VSS ) ),
  E100_4 ( .SIDDQ( siddq ), .Iout( I_REXT_100_netclash[4] ), .Pcasc(
Pcasc1 ), .VDD( VDD ), .Pbias( Pbias1 ), .VSS( VSS ) ),
  E100_3 ( .SIDDQ( siddq ), .Iout( I_REXT_100_netclash[3] ), .Pcasc(
Pcasc1 ), .VDD( VDD ), .Pbias( Pbias1 ), .VSS( VSS ) ),
  E100_2 ( .SIDDQ( siddq ), .Iout( I_REXT_100_netclash[2] ), .Pcasc(
Pcasc1 ), .VDD( VDD ), .Pbias( Pbias1 ), .VSS( VSS ) ),
  E100_1 ( .SIDDQ( siddq ), .Iout( I_REXT_100_netclash[1] ), .Pcasc(
Pcasc1 ), .VDD( VDD ), .Pbias( Pbias1 ), .VSS( VSS ) ),
  E100_0 ( .SIDDQ( siddq ), .Iout( I_REXT_100_netclash[0] ), .Pcasc(
Pcasc1 ), .VDD( VDD ), .Pbias( Pbias1 ), .VSS( VSS ) );

endmodule
