// Verilog-AMS netlist generated by the AMS netlister, version ICOA5.2.51.500.7.
// Cadence Design Systems, Inc.

`include "disciplines.vams"

module PLL_VCO_250MHZ_INV ( VDD,Y,VSS,A );

input   VDD;
output   Y;
input   VSS;
input   A;

gpdk090_nmoscap2v #(.m(1 * 1), .l(910n), .w(905n)) (*
integer
library_binding = "gpdk090";
integer passed_mfactor = "m";
integer
elaboration_binding = "C0[7:0]";
 *)
C0_7 ( VSS, Y, VSS, VSS ),
  C0_6 ( VSS, Y, VSS, VSS ),
  C0_5 ( VSS, Y, VSS, VSS ),
  C0_4 ( VSS, Y, VSS, VSS ),
  C0_3 ( VSS, Y, VSS, VSS ),
  C0_2 ( VSS, Y, VSS, VSS ),
  C0_1 ( VSS, Y, VSS, VSS ),
  C0_0 ( VSS, Y, VSS, VSS );

gpdk090_pmos2v #(.ps(9.9u), .m(1 * 4), .as(2.7p), .l(280.0n), .pd(6.6u),
 .ad(1.8p), .w(6u)) (*
integer library_binding = "gpdk090";
integer
passed_mfactor = "m";
 *)
PM0 ( Y, A, VDD, VDD );

gpdk090_nmos2v #(.ps(5.4u), .m(1 * 4), .as(1.35p), .l(280.0n), .pd(3.6u),
 .ad(900f), .w(3u)) (*
integer library_binding = "gpdk090";
integer
passed_mfactor = "m";
 *)
NM0 ( Y, A, VSS, VSS );

endmodule
