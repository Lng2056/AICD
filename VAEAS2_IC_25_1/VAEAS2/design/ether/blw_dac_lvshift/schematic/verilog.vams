// Verilog-AMS netlist generated by the AMS netlister, version ICOA5.2.51.500.7.
// Cadence Design Systems, Inc.

`include "disciplines.vams"

module blw_dac_lvshift ( up_1v,AVDD_2p5V,DVDD,down_1v,up_2p5v,AGND,
down_2p5v );

input [62:0]  up_1v;
input   AVDD_2p5V;
input   DVDD;
input [62:0]
 down_1v;
output [62:0]  up_2p5v;
input   AGND;
output [62:0]
 down_2p5v;

level_shifter_1p0_2p5 (*
integer library_binding = "ether";
integer
elaboration_binding = "I1[62:0]";
 *)
I1_62 ( .IN( down_1v[62] ), .VDD_1p0(
DVDD ), .VDD_2p5( AVDD_2p5V ), .OUT( down_2p5v[62] ), .VSS( AGND ) ),
  I1_61 ( .IN( down_1v[61] ), .VDD_1p0( DVDD ), .VDD_2p5( AVDD_2p5V ),
.OUT( down_2p5v[61] ), .VSS( AGND ) ),
  I1_60 ( .IN( down_1v[60] ), .VDD_1p0( DVDD ), .VDD_2p5( AVDD_2p5V ),
.OUT( down_2p5v[60] ), .VSS( AGND ) ),
  I1_59 ( .IN( down_1v[59] ), .VDD_1p0( DVDD ), .VDD_2p5( AVDD_2p5V ),
.OUT( down_2p5v[59] ), .VSS( AGND ) ),
  I1_58 ( .IN( down_1v[58] ), .VDD_1p0( DVDD ), .VDD_2p5( AVDD_2p5V ),
.OUT( down_2p5v[58] ), .VSS( AGND ) ),
  I1_57 ( .IN( down_1v[57] ), .VDD_1p0( DVDD ), .VDD_2p5( AVDD_2p5V ),
.OUT( down_2p5v[57] ), .VSS( AGND ) ),
  I1_56 ( .IN( down_1v[56] ), .VDD_1p0( DVDD ), .VDD_2p5( AVDD_2p5V ),
.OUT( down_2p5v[56] ), .VSS( AGND ) ),
  I1_55 ( .IN( down_1v[55] ), .VDD_1p0( DVDD ), .VDD_2p5( AVDD_2p5V ),
.OUT( down_2p5v[55] ), .VSS( AGND ) ),
  I1_54 ( .IN( down_1v[54] ), .VDD_1p0( DVDD ), .VDD_2p5( AVDD_2p5V ),
.OUT( down_2p5v[54] ), .VSS( AGND ) ),
  I1_53 ( .IN( down_1v[53] ), .VDD_1p0( DVDD ), .VDD_2p5( AVDD_2p5V ),
.OUT( down_2p5v[53] ), .VSS( AGND ) ),
  I1_52 ( .IN( down_1v[52] ), .VDD_1p0( DVDD ), .VDD_2p5( AVDD_2p5V ),
.OUT( down_2p5v[52] ), .VSS( AGND ) ),
  I1_51 ( .IN( down_1v[51] ), .VDD_1p0( DVDD ), .VDD_2p5( AVDD_2p5V ),
.OUT( down_2p5v[51] ), .VSS( AGND ) ),
  I1_50 ( .IN( down_1v[50] ), .VDD_1p0( DVDD ), .VDD_2p5( AVDD_2p5V ),
.OUT( down_2p5v[50] ), .VSS( AGND ) ),
  I1_49 ( .IN( down_1v[49] ), .VDD_1p0( DVDD ), .VDD_2p5( AVDD_2p5V ),
.OUT( down_2p5v[49] ), .VSS( AGND ) ),
  I1_48 ( .IN( down_1v[48] ), .VDD_1p0( DVDD ), .VDD_2p5( AVDD_2p5V ),
.OUT( down_2p5v[48] ), .VSS( AGND ) ),
  I1_47 ( .IN( down_1v[47] ), .VDD_1p0( DVDD ), .VDD_2p5( AVDD_2p5V ),
.OUT( down_2p5v[47] ), .VSS( AGND ) ),
  I1_46 ( .IN( down_1v[46] ), .VDD_1p0( DVDD ), .VDD_2p5( AVDD_2p5V ),
.OUT( down_2p5v[46] ), .VSS( AGND ) ),
  I1_45 ( .IN( down_1v[45] ), .VDD_1p0( DVDD ), .VDD_2p5( AVDD_2p5V ),
.OUT( down_2p5v[45] ), .VSS( AGND ) ),
  I1_44 ( .IN( down_1v[44] ), .VDD_1p0( DVDD ), .VDD_2p5( AVDD_2p5V ),
.OUT( down_2p5v[44] ), .VSS( AGND ) ),
  I1_43 ( .IN( down_1v[43] ), .VDD_1p0( DVDD ), .VDD_2p5( AVDD_2p5V ),
.OUT( down_2p5v[43] ), .VSS( AGND ) ),
  I1_42 ( .IN( down_1v[42] ), .VDD_1p0( DVDD ), .VDD_2p5( AVDD_2p5V ),
.OUT( down_2p5v[42] ), .VSS( AGND ) ),
  I1_41 ( .IN( down_1v[41] ), .VDD_1p0( DVDD ), .VDD_2p5( AVDD_2p5V ),
.OUT( down_2p5v[41] ), .VSS( AGND ) ),
  I1_40 ( .IN( down_1v[40] ), .VDD_1p0( DVDD ), .VDD_2p5( AVDD_2p5V ),
.OUT( down_2p5v[40] ), .VSS( AGND ) ),
  I1_39 ( .IN( down_1v[39] ), .VDD_1p0( DVDD ), .VDD_2p5( AVDD_2p5V ),
.OUT( down_2p5v[39] ), .VSS( AGND ) ),
  I1_38 ( .IN( down_1v[38] ), .VDD_1p0( DVDD ), .VDD_2p5( AVDD_2p5V ),
.OUT( down_2p5v[38] ), .VSS( AGND ) ),
  I1_37 ( .IN( down_1v[37] ), .VDD_1p0( DVDD ), .VDD_2p5( AVDD_2p5V ),
.OUT( down_2p5v[37] ), .VSS( AGND ) ),
  I1_36 ( .IN( down_1v[36] ), .VDD_1p0( DVDD ), .VDD_2p5( AVDD_2p5V ),
.OUT( down_2p5v[36] ), .VSS( AGND ) ),
  I1_35 ( .IN( down_1v[35] ), .VDD_1p0( DVDD ), .VDD_2p5( AVDD_2p5V ),
.OUT( down_2p5v[35] ), .VSS( AGND ) ),
  I1_34 ( .IN( down_1v[34] ), .VDD_1p0( DVDD ), .VDD_2p5( AVDD_2p5V ),
.OUT( down_2p5v[34] ), .VSS( AGND ) ),
  I1_33 ( .IN( down_1v[33] ), .VDD_1p0( DVDD ), .VDD_2p5( AVDD_2p5V ),
.OUT( down_2p5v[33] ), .VSS( AGND ) ),
  I1_32 ( .IN( down_1v[32] ), .VDD_1p0( DVDD ), .VDD_2p5( AVDD_2p5V ),
.OUT( down_2p5v[32] ), .VSS( AGND ) ),
  I1_31 ( .IN( down_1v[31] ), .VDD_1p0( DVDD ), .VDD_2p5( AVDD_2p5V ),
.OUT( down_2p5v[31] ), .VSS( AGND ) ),
  I1_30 ( .IN( down_1v[30] ), .VDD_1p0( DVDD ), .VDD_2p5( AVDD_2p5V ),
.OUT( down_2p5v[30] ), .VSS( AGND ) ),
  I1_29 ( .IN( down_1v[29] ), .VDD_1p0( DVDD ), .VDD_2p5( AVDD_2p5V ),
.OUT( down_2p5v[29] ), .VSS( AGND ) ),
  I1_28 ( .IN( down_1v[28] ), .VDD_1p0( DVDD ), .VDD_2p5( AVDD_2p5V ),
.OUT( down_2p5v[28] ), .VSS( AGND ) ),
  I1_27 ( .IN( down_1v[27] ), .VDD_1p0( DVDD ), .VDD_2p5( AVDD_2p5V ),
.OUT( down_2p5v[27] ), .VSS( AGND ) ),
  I1_26 ( .IN( down_1v[26] ), .VDD_1p0( DVDD ), .VDD_2p5( AVDD_2p5V ),
.OUT( down_2p5v[26] ), .VSS( AGND ) ),
  I1_25 ( .IN( down_1v[25] ), .VDD_1p0( DVDD ), .VDD_2p5( AVDD_2p5V ),
.OUT( down_2p5v[25] ), .VSS( AGND ) ),
  I1_24 ( .IN( down_1v[24] ), .VDD_1p0( DVDD ), .VDD_2p5( AVDD_2p5V ),
.OUT( down_2p5v[24] ), .VSS( AGND ) ),
  I1_23 ( .IN( down_1v[23] ), .VDD_1p0( DVDD ), .VDD_2p5( AVDD_2p5V ),
.OUT( down_2p5v[23] ), .VSS( AGND ) ),
  I1_22 ( .IN( down_1v[22] ), .VDD_1p0( DVDD ), .VDD_2p5( AVDD_2p5V ),
.OUT( down_2p5v[22] ), .VSS( AGND ) ),
  I1_21 ( .IN( down_1v[21] ), .VDD_1p0( DVDD ), .VDD_2p5( AVDD_2p5V ),
.OUT( down_2p5v[21] ), .VSS( AGND ) ),
  I1_20 ( .IN( down_1v[20] ), .VDD_1p0( DVDD ), .VDD_2p5( AVDD_2p5V ),
.OUT( down_2p5v[20] ), .VSS( AGND ) ),
  I1_19 ( .IN( down_1v[19] ), .VDD_1p0( DVDD ), .VDD_2p5( AVDD_2p5V ),
.OUT( down_2p5v[19] ), .VSS( AGND ) ),
  I1_18 ( .IN( down_1v[18] ), .VDD_1p0( DVDD ), .VDD_2p5( AVDD_2p5V ),
.OUT( down_2p5v[18] ), .VSS( AGND ) ),
  I1_17 ( .IN( down_1v[17] ), .VDD_1p0( DVDD ), .VDD_2p5( AVDD_2p5V ),
.OUT( down_2p5v[17] ), .VSS( AGND ) ),
  I1_16 ( .IN( down_1v[16] ), .VDD_1p0( DVDD ), .VDD_2p5( AVDD_2p5V ),
.OUT( down_2p5v[16] ), .VSS( AGND ) ),
  I1_15 ( .IN( down_1v[15] ), .VDD_1p0( DVDD ), .VDD_2p5( AVDD_2p5V ),
.OUT( down_2p5v[15] ), .VSS( AGND ) ),
  I1_14 ( .IN( down_1v[14] ), .VDD_1p0( DVDD ), .VDD_2p5( AVDD_2p5V ),
.OUT( down_2p5v[14] ), .VSS( AGND ) ),
  I1_13 ( .IN( down_1v[13] ), .VDD_1p0( DVDD ), .VDD_2p5( AVDD_2p5V ),
.OUT( down_2p5v[13] ), .VSS( AGND ) ),
  I1_12 ( .IN( down_1v[12] ), .VDD_1p0( DVDD ), .VDD_2p5( AVDD_2p5V ),
.OUT( down_2p5v[12] ), .VSS( AGND ) ),
  I1_11 ( .IN( down_1v[11] ), .VDD_1p0( DVDD ), .VDD_2p5( AVDD_2p5V ),
.OUT( down_2p5v[11] ), .VSS( AGND ) ),
  I1_10 ( .IN( down_1v[10] ), .VDD_1p0( DVDD ), .VDD_2p5( AVDD_2p5V ),
.OUT( down_2p5v[10] ), .VSS( AGND ) ),
  I1_9 ( .IN( down_1v[9] ), .VDD_1p0( DVDD ), .VDD_2p5( AVDD_2p5V ), .OUT(
down_2p5v[9] ), .VSS( AGND ) ),
  I1_8 ( .IN( down_1v[8] ), .VDD_1p0( DVDD ), .VDD_2p5( AVDD_2p5V ), .OUT(
down_2p5v[8] ), .VSS( AGND ) ),
  I1_7 ( .IN( down_1v[7] ), .VDD_1p0( DVDD ), .VDD_2p5( AVDD_2p5V ), .OUT(
down_2p5v[7] ), .VSS( AGND ) ),
  I1_6 ( .IN( down_1v[6] ), .VDD_1p0( DVDD ), .VDD_2p5( AVDD_2p5V ), .OUT(
down_2p5v[6] ), .VSS( AGND ) ),
  I1_5 ( .IN( down_1v[5] ), .VDD_1p0( DVDD ), .VDD_2p5( AVDD_2p5V ), .OUT(
down_2p5v[5] ), .VSS( AGND ) ),
  I1_4 ( .IN( down_1v[4] ), .VDD_1p0( DVDD ), .VDD_2p5( AVDD_2p5V ), .OUT(
down_2p5v[4] ), .VSS( AGND ) ),
  I1_3 ( .IN( down_1v[3] ), .VDD_1p0( DVDD ), .VDD_2p5( AVDD_2p5V ), .OUT(
down_2p5v[3] ), .VSS( AGND ) ),
  I1_2 ( .IN( down_1v[2] ), .VDD_1p0( DVDD ), .VDD_2p5( AVDD_2p5V ), .OUT(
down_2p5v[2] ), .VSS( AGND ) ),
  I1_1 ( .IN( down_1v[1] ), .VDD_1p0( DVDD ), .VDD_2p5( AVDD_2p5V ), .OUT(
down_2p5v[1] ), .VSS( AGND ) ),
  I1_0 ( .IN( down_1v[0] ), .VDD_1p0( DVDD ), .VDD_2p5( AVDD_2p5V ), .OUT(
down_2p5v[0] ), .VSS( AGND ) );
level_shifter_1p0_2p5 (*
integer library_binding = "ether";
integer
elaboration_binding = "I0[62:0]";
 *)
I0_62 ( .IN( up_1v[62] ), .VDD_1p0(
DVDD ), .VDD_2p5( AVDD_2p5V ), .OUT( up_2p5v[62] ), .VSS( AGND ) ),
  I0_61 ( .IN( up_1v[61] ), .VDD_1p0( DVDD ), .VDD_2p5( AVDD_2p5V ), .OUT(
up_2p5v[61] ), .VSS( AGND ) ),
  I0_60 ( .IN( up_1v[60] ), .VDD_1p0( DVDD ), .VDD_2p5( AVDD_2p5V ), .OUT(
up_2p5v[60] ), .VSS( AGND ) ),
  I0_59 ( .IN( up_1v[59] ), .VDD_1p0( DVDD ), .VDD_2p5( AVDD_2p5V ), .OUT(
up_2p5v[59] ), .VSS( AGND ) ),
  I0_58 ( .IN( up_1v[58] ), .VDD_1p0( DVDD ), .VDD_2p5( AVDD_2p5V ), .OUT(
up_2p5v[58] ), .VSS( AGND ) ),
  I0_57 ( .IN( up_1v[57] ), .VDD_1p0( DVDD ), .VDD_2p5( AVDD_2p5V ), .OUT(
up_2p5v[57] ), .VSS( AGND ) ),
  I0_56 ( .IN( up_1v[56] ), .VDD_1p0( DVDD ), .VDD_2p5( AVDD_2p5V ), .OUT(
up_2p5v[56] ), .VSS( AGND ) ),
  I0_55 ( .IN( up_1v[55] ), .VDD_1p0( DVDD ), .VDD_2p5( AVDD_2p5V ), .OUT(
up_2p5v[55] ), .VSS( AGND ) ),
  I0_54 ( .IN( up_1v[54] ), .VDD_1p0( DVDD ), .VDD_2p5( AVDD_2p5V ), .OUT(
up_2p5v[54] ), .VSS( AGND ) ),
  I0_53 ( .IN( up_1v[53] ), .VDD_1p0( DVDD ), .VDD_2p5( AVDD_2p5V ), .OUT(
up_2p5v[53] ), .VSS( AGND ) ),
  I0_52 ( .IN( up_1v[52] ), .VDD_1p0( DVDD ), .VDD_2p5( AVDD_2p5V ), .OUT(
up_2p5v[52] ), .VSS( AGND ) ),
  I0_51 ( .IN( up_1v[51] ), .VDD_1p0( DVDD ), .VDD_2p5( AVDD_2p5V ), .OUT(
up_2p5v[51] ), .VSS( AGND ) ),
  I0_50 ( .IN( up_1v[50] ), .VDD_1p0( DVDD ), .VDD_2p5( AVDD_2p5V ), .OUT(
up_2p5v[50] ), .VSS( AGND ) ),
  I0_49 ( .IN( up_1v[49] ), .VDD_1p0( DVDD ), .VDD_2p5( AVDD_2p5V ), .OUT(
up_2p5v[49] ), .VSS( AGND ) ),
  I0_48 ( .IN( up_1v[48] ), .VDD_1p0( DVDD ), .VDD_2p5( AVDD_2p5V ), .OUT(
up_2p5v[48] ), .VSS( AGND ) ),
  I0_47 ( .IN( up_1v[47] ), .VDD_1p0( DVDD ), .VDD_2p5( AVDD_2p5V ), .OUT(
up_2p5v[47] ), .VSS( AGND ) ),
  I0_46 ( .IN( up_1v[46] ), .VDD_1p0( DVDD ), .VDD_2p5( AVDD_2p5V ), .OUT(
up_2p5v[46] ), .VSS( AGND ) ),
  I0_45 ( .IN( up_1v[45] ), .VDD_1p0( DVDD ), .VDD_2p5( AVDD_2p5V ), .OUT(
up_2p5v[45] ), .VSS( AGND ) ),
  I0_44 ( .IN( up_1v[44] ), .VDD_1p0( DVDD ), .VDD_2p5( AVDD_2p5V ), .OUT(
up_2p5v[44] ), .VSS( AGND ) ),
  I0_43 ( .IN( up_1v[43] ), .VDD_1p0( DVDD ), .VDD_2p5( AVDD_2p5V ), .OUT(
up_2p5v[43] ), .VSS( AGND ) ),
  I0_42 ( .IN( up_1v[42] ), .VDD_1p0( DVDD ), .VDD_2p5( AVDD_2p5V ), .OUT(
up_2p5v[42] ), .VSS( AGND ) ),
  I0_41 ( .IN( up_1v[41] ), .VDD_1p0( DVDD ), .VDD_2p5( AVDD_2p5V ), .OUT(
up_2p5v[41] ), .VSS( AGND ) ),
  I0_40 ( .IN( up_1v[40] ), .VDD_1p0( DVDD ), .VDD_2p5( AVDD_2p5V ), .OUT(
up_2p5v[40] ), .VSS( AGND ) ),
  I0_39 ( .IN( up_1v[39] ), .VDD_1p0( DVDD ), .VDD_2p5( AVDD_2p5V ), .OUT(
up_2p5v[39] ), .VSS( AGND ) ),
  I0_38 ( .IN( up_1v[38] ), .VDD_1p0( DVDD ), .VDD_2p5( AVDD_2p5V ), .OUT(
up_2p5v[38] ), .VSS( AGND ) ),
  I0_37 ( .IN( up_1v[37] ), .VDD_1p0( DVDD ), .VDD_2p5( AVDD_2p5V ), .OUT(
up_2p5v[37] ), .VSS( AGND ) ),
  I0_36 ( .IN( up_1v[36] ), .VDD_1p0( DVDD ), .VDD_2p5( AVDD_2p5V ), .OUT(
up_2p5v[36] ), .VSS( AGND ) ),
  I0_35 ( .IN( up_1v[35] ), .VDD_1p0( DVDD ), .VDD_2p5( AVDD_2p5V ), .OUT(
up_2p5v[35] ), .VSS( AGND ) ),
  I0_34 ( .IN( up_1v[34] ), .VDD_1p0( DVDD ), .VDD_2p5( AVDD_2p5V ), .OUT(
up_2p5v[34] ), .VSS( AGND ) ),
  I0_33 ( .IN( up_1v[33] ), .VDD_1p0( DVDD ), .VDD_2p5( AVDD_2p5V ), .OUT(
up_2p5v[33] ), .VSS( AGND ) ),
  I0_32 ( .IN( up_1v[32] ), .VDD_1p0( DVDD ), .VDD_2p5( AVDD_2p5V ), .OUT(
up_2p5v[32] ), .VSS( AGND ) ),
  I0_31 ( .IN( up_1v[31] ), .VDD_1p0( DVDD ), .VDD_2p5( AVDD_2p5V ), .OUT(
up_2p5v[31] ), .VSS( AGND ) ),
  I0_30 ( .IN( up_1v[30] ), .VDD_1p0( DVDD ), .VDD_2p5( AVDD_2p5V ), .OUT(
up_2p5v[30] ), .VSS( AGND ) ),
  I0_29 ( .IN( up_1v[29] ), .VDD_1p0( DVDD ), .VDD_2p5( AVDD_2p5V ), .OUT(
up_2p5v[29] ), .VSS( AGND ) ),
  I0_28 ( .IN( up_1v[28] ), .VDD_1p0( DVDD ), .VDD_2p5( AVDD_2p5V ), .OUT(
up_2p5v[28] ), .VSS( AGND ) ),
  I0_27 ( .IN( up_1v[27] ), .VDD_1p0( DVDD ), .VDD_2p5( AVDD_2p5V ), .OUT(
up_2p5v[27] ), .VSS( AGND ) ),
  I0_26 ( .IN( up_1v[26] ), .VDD_1p0( DVDD ), .VDD_2p5( AVDD_2p5V ), .OUT(
up_2p5v[26] ), .VSS( AGND ) ),
  I0_25 ( .IN( up_1v[25] ), .VDD_1p0( DVDD ), .VDD_2p5( AVDD_2p5V ), .OUT(
up_2p5v[25] ), .VSS( AGND ) ),
  I0_24 ( .IN( up_1v[24] ), .VDD_1p0( DVDD ), .VDD_2p5( AVDD_2p5V ), .OUT(
up_2p5v[24] ), .VSS( AGND ) ),
  I0_23 ( .IN( up_1v[23] ), .VDD_1p0( DVDD ), .VDD_2p5( AVDD_2p5V ), .OUT(
up_2p5v[23] ), .VSS( AGND ) ),
  I0_22 ( .IN( up_1v[22] ), .VDD_1p0( DVDD ), .VDD_2p5( AVDD_2p5V ), .OUT(
up_2p5v[22] ), .VSS( AGND ) ),
  I0_21 ( .IN( up_1v[21] ), .VDD_1p0( DVDD ), .VDD_2p5( AVDD_2p5V ), .OUT(
up_2p5v[21] ), .VSS( AGND ) ),
  I0_20 ( .IN( up_1v[20] ), .VDD_1p0( DVDD ), .VDD_2p5( AVDD_2p5V ), .OUT(
up_2p5v[20] ), .VSS( AGND ) ),
  I0_19 ( .IN( up_1v[19] ), .VDD_1p0( DVDD ), .VDD_2p5( AVDD_2p5V ), .OUT(
up_2p5v[19] ), .VSS( AGND ) ),
  I0_18 ( .IN( up_1v[18] ), .VDD_1p0( DVDD ), .VDD_2p5( AVDD_2p5V ), .OUT(
up_2p5v[18] ), .VSS( AGND ) ),
  I0_17 ( .IN( up_1v[17] ), .VDD_1p0( DVDD ), .VDD_2p5( AVDD_2p5V ), .OUT(
up_2p5v[17] ), .VSS( AGND ) ),
  I0_16 ( .IN( up_1v[16] ), .VDD_1p0( DVDD ), .VDD_2p5( AVDD_2p5V ), .OUT(
up_2p5v[16] ), .VSS( AGND ) ),
  I0_15 ( .IN( up_1v[15] ), .VDD_1p0( DVDD ), .VDD_2p5( AVDD_2p5V ), .OUT(
up_2p5v[15] ), .VSS( AGND ) ),
  I0_14 ( .IN( up_1v[14] ), .VDD_1p0( DVDD ), .VDD_2p5( AVDD_2p5V ), .OUT(
up_2p5v[14] ), .VSS( AGND ) ),
  I0_13 ( .IN( up_1v[13] ), .VDD_1p0( DVDD ), .VDD_2p5( AVDD_2p5V ), .OUT(
up_2p5v[13] ), .VSS( AGND ) ),
  I0_12 ( .IN( up_1v[12] ), .VDD_1p0( DVDD ), .VDD_2p5( AVDD_2p5V ), .OUT(
up_2p5v[12] ), .VSS( AGND ) ),
  I0_11 ( .IN( up_1v[11] ), .VDD_1p0( DVDD ), .VDD_2p5( AVDD_2p5V ), .OUT(
up_2p5v[11] ), .VSS( AGND ) ),
  I0_10 ( .IN( up_1v[10] ), .VDD_1p0( DVDD ), .VDD_2p5( AVDD_2p5V ), .OUT(
up_2p5v[10] ), .VSS( AGND ) ),
  I0_9 ( .IN( up_1v[9] ), .VDD_1p0( DVDD ), .VDD_2p5( AVDD_2p5V ), .OUT(
up_2p5v[9] ), .VSS( AGND ) ),
  I0_8 ( .IN( up_1v[8] ), .VDD_1p0( DVDD ), .VDD_2p5( AVDD_2p5V ), .OUT(
up_2p5v[8] ), .VSS( AGND ) ),
  I0_7 ( .IN( up_1v[7] ), .VDD_1p0( DVDD ), .VDD_2p5( AVDD_2p5V ), .OUT(
up_2p5v[7] ), .VSS( AGND ) ),
  I0_6 ( .IN( up_1v[6] ), .VDD_1p0( DVDD ), .VDD_2p5( AVDD_2p5V ), .OUT(
up_2p5v[6] ), .VSS( AGND ) ),
  I0_5 ( .IN( up_1v[5] ), .VDD_1p0( DVDD ), .VDD_2p5( AVDD_2p5V ), .OUT(
up_2p5v[5] ), .VSS( AGND ) ),
  I0_4 ( .IN( up_1v[4] ), .VDD_1p0( DVDD ), .VDD_2p5( AVDD_2p5V ), .OUT(
up_2p5v[4] ), .VSS( AGND ) ),
  I0_3 ( .IN( up_1v[3] ), .VDD_1p0( DVDD ), .VDD_2p5( AVDD_2p5V ), .OUT(
up_2p5v[3] ), .VSS( AGND ) ),
  I0_2 ( .IN( up_1v[2] ), .VDD_1p0( DVDD ), .VDD_2p5( AVDD_2p5V ), .OUT(
up_2p5v[2] ), .VSS( AGND ) ),
  I0_1 ( .IN( up_1v[1] ), .VDD_1p0( DVDD ), .VDD_2p5( AVDD_2p5V ), .OUT(
up_2p5v[1] ), .VSS( AGND ) ),
  I0_0 ( .IN( up_1v[0] ), .VDD_1p0( DVDD ), .VDD_2p5( AVDD_2p5V ), .OUT(
up_2p5v[0] ), .VSS( AGND ) );

endmodule
