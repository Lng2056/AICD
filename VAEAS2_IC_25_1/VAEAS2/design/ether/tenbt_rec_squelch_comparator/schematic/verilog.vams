// Verilog-AMS netlist generated by the AMS netlister, version ICOA5.2.51.500.7.
// Cadence Design Systems, Inc.

`include "disciplines.vams"

module tenbt_rec_squelch_comparator ( gnd,vbias,vdd,Vbias_Poly,in_neg,
siddq,out,in_pos );

input   gnd;
input   vbias;
input   vdd;
input   Vbias_Poly;
input
 in_neg;
input   siddq;
output   out;
input   in_pos;

gpdk090_resnsppoly #(.w(2u), .r(10K), .l(49.9943u)) (*
integer
library_binding = "gpdk090";
 *)
R3 ( vdd, net21, gnd );
gpdk090_resnsppoly #(.w(2u), .r(10K), .l(49.9943u)) (*
integer
library_binding = "gpdk090";
 *)
R0 ( net075, net0141, gnd );
gpdk090_resnsppoly #(.w(2u), .r(3.99945K), .l(19.9843u)) (*
integer
library_binding = "gpdk090";
 *)
R6 ( vdd, net075, gnd );
gpdk090_resnsppoly #(.w(2u), .r(10K), .l(49.9943u)) (*
integer
library_binding = "gpdk090";
 *)
R4 ( vdd, net0103, gnd );
gpdk090_resnsppoly #(.w(2u), .r(10K), .l(49.9943u)) (*
integer
library_binding = "gpdk090";
 *)
R1 ( net075, net0137, gnd );

gpdk090_pmos2v #(.ps(2.8u), .m(1 * 1), .as(462f), .l(280.0n), .pd(2.8u),
 .ad(462f), .w(510n)) (*
integer library_binding = "gpdk090";
integer
passed_mfactor = "m";
 *)
PM0 ( net220, net69, vdd, vdd );
gpdk090_pmos2v #(.ps(2.8u), .m(1 * 1), .as(462f), .l(280.0n), .pd(2.8u),
 .ad(462f), .w(510n)) (*
integer library_binding = "gpdk090";
integer
passed_mfactor = "m";
 *)
PM7 ( net39, net69, vdd, vdd );
gpdk090_pmos2v #(.ps(2.8u), .m(1 * 1), .as(462f), .l(280.0n), .pd(2.8u),
 .ad(462f), .w(510n)) (*
integer library_binding = "gpdk090";
integer
passed_mfactor = "m";
 *)
PM12 ( net106, net69, vdd, vdd );
gpdk090_pmos2v #(.ps(2.8u), .m(1 * 1), .as(462f), .l(280.0n), .pd(2.8u),
 .ad(462f), .w(510n)) (*
integer library_binding = "gpdk090";
integer
passed_mfactor = "m";
 *)
PM13 ( single_end_sq, net69, vdd, vdd );
gpdk090_pmos2v #(.ps(2.8u), .m(1 * 1), .as(462f), .l(280.0n), .pd(2.8u),
 .ad(462f), .w(510n)) (*
integer library_binding = "gpdk090";
integer
passed_mfactor = "m";
 *)
PM1 ( net0188, net69, vdd, vdd );
gpdk090_pmos2v #(.ps(2.8u), .m(1 * 1), .as(462f), .l(280.0n), .pd(2.8u),
 .ad(462f), .w(510n)) (*
integer library_binding = "gpdk090";
integer
passed_mfactor = "m";
 *)
PM3 ( net52, net69, vdd, vdd );
gpdk090_pmos2v #(.ps(15.2u), .m(1 * 2), .as(4.2p), .l(280.0n), .pd(7.6u),
 .ad(2.1p), .w(7u)) (*
integer library_binding = "gpdk090";
integer
passed_mfactor = "m";
 *)
PM2 ( single_end_sq, net106, vdd, vdd );
gpdk090_pmos2v #(.ps(15.2u), .m(1 * 2), .as(4.2p), .l(280.0n), .pd(7.6u),
 .ad(2.1p), .w(7u)) (*
integer library_binding = "gpdk090";
integer
passed_mfactor = "m";
 *)
PM5 ( net39, net39, vdd, vdd );
gpdk090_pmos2v #(.ps(15.2u), .m(1 * 2), .as(4.2p), .l(280.0n), .pd(7.6u),
 .ad(2.1p), .w(7u)) (*
integer library_binding = "gpdk090";
integer
passed_mfactor = "m";
 *)
PM4 ( net106, net106, vdd, vdd );
gpdk090_pmos2v #(.ps(15.2u), .m(1 * 2), .as(4.2p), .l(280.0n), .pd(7.6u),
 .ad(2.1p), .w(7u)) (*
integer library_binding = "gpdk090";
integer
passed_mfactor = "m";
 *)
PM6 ( net0123, net39, vdd, vdd );

gpdk090_nmos2v #(.ps(37.2u), .m(1 * 1), .as(10.8p), .l(2u), .pd(37.2u),
 .ad(10.8p), .w(18u)) (*
integer library_binding = "gpdk090";
integer
passed_mfactor = "m";
 *)
NM4 ( net220, Vbias_Poly, gnd, gnd );
gpdk090_nmos2v #(.ps(7.2u), .m(1 * 2), .as(1.8p), .l(280.0n), .pd(3.6u),
 .ad(900f), .w(3u)) (*
integer library_binding = "gpdk090";
integer
passed_mfactor = "m";
 *)
NM7 ( net21, net0141, net0188, gnd );
gpdk090_nmos2v #(.ps(7.2u), .m(1 * 2), .as(1.8p), .l(280.0n), .pd(3.6u),
 .ad(900f), .w(3u)) (*
integer library_binding = "gpdk090";
integer
passed_mfactor = "m";
 *)
NM10 ( net106, net0103, net52, gnd );
gpdk090_nmos2v #(.ps(2.8u), .m(1 * 1), .as(462f), .l(280.0n), .pd(2.8u),
 .ad(462f), .w(510n)) (*
integer library_binding = "gpdk090";
integer
passed_mfactor = "m";
 *)
NM18 ( net0123, siddq, gnd, gnd );
gpdk090_nmos2v #(.ps(37.2u), .m(1 * 2), .as(10.8p), .l(2u), .pd(18.6u),
 .ad(5.4p), .w(18u)) (*
integer library_binding = "gpdk090";
integer
passed_mfactor = "m";
 *)
NM2 ( net0188, Vbias_Poly, gnd, gnd );
gpdk090_nmos2v #(.ps(7.2u), .m(1 * 2), .as(1.8p), .l(280.0n), .pd(3.6u),
 .ad(900f), .w(3u)) (*
integer library_binding = "gpdk090";
integer
passed_mfactor = "m";
 *)
NM6 ( net0103, net0137, net0188, gnd );
gpdk090_nmos2v #(.ps(7.2u), .m(1 * 2), .as(1.8p), .l(280.0n), .pd(3.6u),
 .ad(900f), .w(3u)) (*
integer library_binding = "gpdk090";
integer
passed_mfactor = "m";
 *)
NM5 ( net0137, in_neg, net220, gnd );
gpdk090_nmos2v #(.ps(5.87u), .m(1 * 2), .as(1.401p), .l(280.0n), .pd(2.935u),
 .ad(700.5f), .w(2.335u)) (*
integer library_binding = "gpdk090";

integer passed_mfactor = "m";
 *)
NM16 ( single_end_sq, net0123, gnd,
gnd );
gpdk090_nmos2v #(.ps(7.2u), .m(1 * 2), .as(1.8p), .l(280.0n), .pd(3.6u),
 .ad(900f), .w(3u)) (*
integer library_binding = "gpdk090";
integer
passed_mfactor = "m";
 *)
NM9 ( net39, net21, net52, gnd );
gpdk090_nmos2v #(.ps(5.87u), .m(1 * 2), .as(1.401p), .l(280.0n), .pd(2.935u),
 .ad(700.5f), .w(2.335u)) (*
integer library_binding = "gpdk090";

integer passed_mfactor = "m";
 *)
NM13 ( net0123, net0123, gnd, gnd );
gpdk090_nmos2v #(.ps(21.2u), .m(1 * 2), .as(6p), .l(2u), .pd(10.6u), .ad(3p),
 .w(10u)) (*
integer library_binding = "gpdk090";
integer
passed_mfactor = "m";
 *)
NM11 ( net52, vbias, gnd, gnd );
gpdk090_nmos2v #(.ps(7.2u), .m(1 * 2), .as(1.8p), .l(280.0n), .pd(3.6u),
 .ad(900f), .w(3u)) (*
integer library_binding = "gpdk090";
integer
passed_mfactor = "m";
 *)
NM3 ( net0141, in_pos, net220, gnd );

inv_8x_hv (*
integer library_binding = "ether";
integer cds_net_set
[0:1] = { "DVSS","DVDD" };
integer DVSS = "gnd";
integer DVDD
 = "vdd";
 *)
I14 ( .Y( out ), .A( net092 ) );

inv_4x_hv (*
integer library_binding = "ether";
integer cds_net_set
[0:1] = { "DVDD","DVSS" };
integer DVDD = "vdd";
integer DVSS
 = "gnd";
 *)
I13 ( .Y( net092 ), .A( net090 ) );

inv_3x_hv (*
integer library_binding = "ether";
integer cds_net_set
[0:1] = { "DVSS","DVDD" };
integer DVSS = "gnd";
integer DVDD
 = "vdd";
 *)
I12 ( .Y( net090 ), .A( net088 ) );

inv_2x_hv (*
integer library_binding = "ether";
integer cds_net_set
[0:1] = { "DVDD","DVSS" };
integer DVDD = "vdd";
integer DVSS
 = "gnd";
 *)
I11 ( .Y( net088 ), .A( net096 ) );

inv_1x_hv (*
integer library_binding = "ether";
integer cds_net_set
[0:1] = { "DVDD","DVSS" };
integer DVDD = "vdd";
integer DVSS
 = "gnd";
 *)
I15 ( .Y( net096 ), .A( single_end_sq ) );

inv_1X (*
integer library_binding = "ether";
 *)
I2 ( .vss( gnd ), .VDD(
vdd ), .in( siddq ), .out( net69 ) );

endmodule
