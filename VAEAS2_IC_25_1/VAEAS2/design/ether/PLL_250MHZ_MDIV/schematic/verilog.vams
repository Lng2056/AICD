// Verilog-AMS netlist generated by the AMS netlister, version ICOA5.2.51.500.7.
// Cadence Design Systems, Inc.

`include "disciplines.vams"

module PLL_250MHZ_MDIV ( CLKFB,CLKVCO );

output   CLKFB;
input   CLKVCO;

wire [4:0] qb;
wire [4:0] q;
wire [4:1] d;
wire [4:1] ck;

parameter Threshold=0;
parameter Vpwr=0;
parameter Tprop=0;
parameter Ttrans=0;

or3_1x_hv (*
integer library_binding = "ether";
 *)
I48 ( .C( tieLo ),
.Y( net64 ), .B( q[3] ), .A( q[2] ) );

nor2_2x_hv (*
integer library_binding = "ether";
 *)
I54 ( .Y( cntLt2 ),
.B( net64 ), .A( q[1] ) );

and2_1x_hv (*
integer library_binding = "ether";
 *)
I46 ( .Y( cntZero ),
.B( qb[0] ), .A( cntLt2 ) );

clkbuf_4x_hv (*
integer library_binding = "ether";
 *)
I7 ( .Y( CLKFB ),
.A( divClk ) );

clkbuf_2x_hv (*
integer library_binding = "ether";
 *)
I10 ( .Y( clk ),
.A( CLKVCO ) );

nand2_1x_hv (*
integer library_binding = "ether";
 *)
I40 ( .Y( ck[3] ),
.B( qb[2] ), .A( load ) );
nand2_1x_hv (*
integer library_binding = "ether";
 *)
I37 ( .Y( ck[2] ),
.B( qb[1] ), .A( load ) );
nand2_1x_hv (*
integer library_binding = "ether";
 *)
I20 ( .Y( ck[1] ),
.B( qb[0] ), .A( load ) );
nand2_1x_hv (*
integer library_binding = "ether";
 *)
I57 ( .Y( ck[4] ),
.B( qb[3] ), .A( load ) );

dff_1x_hv (*
integer library_binding = "ether";
 *)
I39 ( .QN( qb[3] ),
.D( d[3] ), .CK( ck[3] ), .Q( q[3] ) );
dff_1x_hv (*
integer library_binding = "ether";
 *)
I33 ( .QN( qb[0] ),
.D( qb[0] ), .CK( clk ), .Q( q[0] ) );
dff_1x_hv (*
integer library_binding = "ether";
 *)
I38 ( .QN( qb[2] ),
.D( d[2] ), .CK( ck[2] ), .Q( q[2] ) );
dff_1x_hv (*
integer library_binding = "ether";
 *)
I17 ( .QN( qb[1] ),
.D( d[1] ), .CK( ck[1] ), .Q( q[1] ) );
dff_1x_hv (*
integer library_binding = "ether";
 *)
I34 ( .QN( load ),
.D( cntZero ), .CK( clk ), .Q( divClk ) );
dff_1x_hv (*
integer library_binding = "ether";
 *)
I59 ( .QN( qb[4] ),
.D( d[4] ), .CK( ck[4] ), .Q( q[4] ) );

mux2inv_1x_hv (*
integer library_binding = "ether";
 *)
I41 ( .S0(
cntLt2 ), .Y( d[3] ), .B( tieLo ), .A( q[3] ) );
mux2inv_1x_hv (*
integer library_binding = "ether";
 *)
I36 ( .S0(
cntLt2 ), .Y( d[2] ), .B( tieHi ), .A( q[2] ) );
mux2inv_1x_hv (*
integer library_binding = "ether";
 *)
I35 ( .S0(
cntLt2 ), .Y( d[1] ), .B( tieHi ), .A( q[1] ) );
mux2inv_1x_hv (*
integer library_binding = "ether";
 *)
I58 ( .S0(
cntLt2 ), .Y( d[4] ), .B( tieHi ), .A( q[4] ) );

tielo_hv (*
integer library_binding = "ether";
 *)
I50 ( .Y( tieLo ) );

tiehi_hv (*
integer library_binding = "ether";
 *)
I49 ( .Y( tieHi ) );

endmodule
