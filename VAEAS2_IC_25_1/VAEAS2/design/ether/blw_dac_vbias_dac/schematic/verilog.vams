// Verilog-AMS netlist generated by the AMS netlister, version ICOA5.2.51.500.7.
// Cadence Design Systems, Inc.

`include "disciplines.vams"

module blw_dac_vbias_dac ( AVDD_2p5V,vbiasp_bit,ibiasp_20u );

input   AVDD_2p5V;
output   vbiasp_bit;
input   ibiasp_20u;

gpdk090_resm3 #(.w(2u), .r(240m), .l(8u)) (*
integer library_binding
 = "gpdk090";
 *)
R2 ( vbiasp_bit, ibiasp_20u );

gpdk090_pmos2v #(.ps(11.2u), .m(2 * 2), .as(3p), .l(2.5u), .pd(5.6u),
.ad(1.5p), .w(5u)) (*
integer library_binding = "gpdk090";
integer
passed_mfactor = "m";
 *)
PM11 ( vbiasp_bit, vbiasp_bit, AVDD_2p5V,
AVDD_2p5V );

endmodule
