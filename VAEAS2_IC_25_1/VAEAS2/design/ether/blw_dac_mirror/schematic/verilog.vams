// Verilog-AMS netlist generated by the AMS netlister, version ICOA5.2.51.500.7.
// Cadence Design Systems, Inc.

`include "disciplines.vams"

module blw_dac_mirror ( dac_I_out,dac_I_in,AGND );

output   dac_I_out;
input   dac_I_in;
input   AGND;

gpdk090_resnsppoly #(.w(2u), .r(7.19877K), .l(35.98u)) (*
integer
library_binding = "gpdk090";
 *)
R1 ( net26, dac_I_in, AGND );

gpdk090_nmoscap2v #(.m(1 * 14), .l(5u), .w(7.075u)) (*
integer
library_binding = "gpdk090";
integer passed_mfactor = "m";
 *)
C1 (
AGND, net26, AGND, AGND );

gpdk090_nmos2v #(.ps(8.4u), .m(8 * 4), .as(2.25p), .l(500n), .pd(5.6u),
 .ad(1.5p), .w(5u)) (*
integer library_binding = "gpdk090";
integer
passed_mfactor = "m";
 *)
NM3 ( dac_I_in, dac_I_in, AGND, AGND );
gpdk090_nmos2v #(.ps(8.4u), .m(8 * 4), .as(2.25p), .l(500n), .pd(5.6u),
 .ad(1.5p), .w(5u)) (*
integer library_binding = "gpdk090";
integer
passed_mfactor = "m";
 *)
NM0 ( dac_I_out, net26, AGND, AGND );

endmodule
