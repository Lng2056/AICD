// Verilog-AMS netlist generated by the AMS netlister, version ICOA5.2.51.500.7.
// Cadence Design Systems, Inc.

`include "disciplines.vams"

module nor2_4x_hv ( Y,B,A );

output   Y;
input   B;
input   A;

wire (*
integer inh_conn_prop_name = "DVDD";
integer
inh_conn_def_value = "cds_globals.\\VDD! ";
 *)
\VDD! ;
wire (*
integer inh_conn_prop_name = "DVSS";
integer
inh_conn_def_value = "cds_globals.\\VSS! ";
 *)
\VSS! ;

gpdk090_pmos2v #(.ps(4.93333u), .m(1 * 3), .as(1.24p), .l(280.0n), .pd(4.93333u),
 .ad(1.24p), .w(3.1u)) (*
integer library_binding = "gpdk090";

integer passed_mfactor = "m";
 *)
PM1 ( Y, A, net027, \VDD!  );
gpdk090_pmos2v #(.ps(4.93333u), .m(1 * 3), .as(1.24p), .l(280.0n), .pd(4.93333u),
 .ad(1.24p), .w(3.1u)) (*
integer library_binding = "gpdk090";

integer passed_mfactor = "m";
 *)
PM0 ( net027, B, \VDD! , \VDD!  );

gpdk090_nmos2v #(.ps(2.2u), .m(1 * 4), .as(362f), .l(280.0n), .pd(1.6u),
 .ad(272f), .w(460n)) (*
integer library_binding = "gpdk090";
integer
passed_mfactor = "m";
 *)
NM0 ( Y, B, \VSS! , \VSS!  );
gpdk090_nmos2v #(.ps(2.2u), .m(1 * 4), .as(362f), .l(280.0n), .pd(1.6u),
 .ad(272f), .w(460n)) (*
integer library_binding = "gpdk090";
integer
passed_mfactor = "m";
 *)
NM1 ( Y, A, \VSS! , \VSS!  );

endmodule
