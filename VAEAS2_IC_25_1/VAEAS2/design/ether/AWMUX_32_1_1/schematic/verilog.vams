// Verilog-AMS netlist generated by the AMS netlister, version ICOA5.2.51.500.7.
// Cadence Design Systems, Inc.

`include "disciplines.vams"

module AWMUX_32_1_1 ( O0,I0,I1,I2,I3,I4,I5,I6,I7,I8,I9,I10,I11,I12,I13,
I14,I15,I16,I17,I18,I19,I20,I21,I22,I23,I24,I25,I26,I27,I28,I29,I30,
I31,S );

output   O0;
input   I0;
input   I1;
input   I2;
input   I3;
input
 I4;
input   I5;
input   I6;
input   I7;
input   I8;
input   I9;

input   I10;
input   I11;
input   I12;
input   I13;
input   I14;

input   I15;
input   I16;
input   I17;
input   I18;
input   I19;

input   I20;
input   I21;
input   I22;
input   I23;
input   I24;

input   I25;
input   I26;
input   I27;
input   I28;
input   I29;

input   I30;
input   I31;
input [4:0]  S;

wire I28;
wire I19;
wire I20;
wire O0;
wire I8;
wire I11;
wire I30;
wire I14;
wire I21;
wire I9;
wire I22;
wire I3;
wire I18;
wire n_141;
wire I10;
wire I0;
wire I12;
wire [4:0] S;
wire I16;
wire n_143;
wire n_130;
wire I27;
wire I2;
wire I7;
wire I17;
wire I29;
wire I1;
wire n_145;
wire n_14;
wire n_17;
wire n_172;
wire n_152;
wire I24;
wire n_165;
wire n_136;
wire I31;
wire n_236;
wire I13;
wire n_159;
wire n_228;
wire I23;
wire I26;
wire n_239;
wire I5;
wire n_206;
wire n_201;
wire I4;
wire I25;
wire n_170;
wire n_229;
wire n_123;
wire I15;
wire n_18;
wire n_238;
wire n_174;
wire n_128;
wire n_157;
wire I6;

AOI21X1 (*
integer library_binding = "gsclib090";
 *)
i_311 ( .A0(
n_238 ), .A1( n_239 ), .B0( S[3] ), .Y( n_236 ) );

INVX1 (*
integer library_binding = "gsclib090";
 *)
i_102 ( .Y( n_228 ),
.A( S[1] ) );
INVX1 (*
integer library_binding = "gsclib090";
 *)
i_103 ( .Y( n_229 ),
.A( S[2] ) );

NAND3X1 (*
integer library_binding = "gsclib090";
 *)
i_73 ( .C( n_228 ),
.Y( n_238 ), .B( S[2] ), .A( n_18 ) );

NAND2X1 (*
integer library_binding = "gsclib090";
 *)
i_314 ( .Y(
n_239 ), .B( n_229 ), .A( n_17 ) );

MX2X1 (*
integer library_binding = "gsclib090";
 *)
i_48 ( .Y( n_165 ),
.S0( S[3] ), .B( I11 ), .A( I3 ) );
MX2X1 (*
integer library_binding = "gsclib090";
 *)
i_53 ( .Y( n_170 ),
.S0( S[3] ), .B( I15 ), .A( I7 ) );
MX2X1 (*
integer library_binding = "gsclib090";
 *)
i_42 ( .Y( n_159 ),
.S0( S[2] ), .B( n_157 ), .A( n_152 ) );
MX2X1 (*
integer library_binding = "gsclib090";
 *)
i_40 ( .Y( n_157 ),
.S0( S[3] ), .B( I13 ), .A( I5 ) );
MX2X1 (*
integer library_binding = "gsclib090";
 *)
i_55 ( .Y( n_172 ),
.S0( S[2] ), .B( n_170 ), .A( n_165 ) );
MX2X1 (*
integer library_binding = "gsclib090";
 *)
i_35 ( .Y( n_152 ),
.S0( S[3] ), .B( I9 ), .A( I1 ) );
MX2X1 (*
integer library_binding = "gsclib090";
 *)
i_57 ( .Y( n_174 ),
.S0( S[1] ), .B( n_172 ), .A( n_159 ) );
MX2X1 (*
integer library_binding = "gsclib090";
 *)
i_28 ( .Y( n_145 ),
.S0( S[1] ), .B( n_143 ), .A( n_130 ) );
MX2X1 (*
integer library_binding = "gsclib090";
 *)
i_26 ( .Y( n_143 ),
.S0( S[2] ), .B( n_141 ), .A( n_136 ) );
MX2X1 (*
integer library_binding = "gsclib090";
 *)
i_24 ( .Y( n_141 ),
.S0( S[3] ), .B( I14 ), .A( I6 ) );
MX2X1 (*
integer library_binding = "gsclib090";
 *)
i_59 ( .Y( n_14 ),
.S0( S[0] ), .B( n_174 ), .A( n_145 ) );
MX2X1 (*
integer library_binding = "gsclib090";
 *)
i_19 ( .Y( n_136 ),
.S0( S[3] ), .B( I10 ), .A( I2 ) );
MX2X1 (*
integer library_binding = "gsclib090";
 *)
i_13 ( .Y( n_130 ),
.S0( S[2] ), .B( n_128 ), .A( n_123 ) );
MX2X1 (*
integer library_binding = "gsclib090";
 *)
i_11 ( .Y( n_128 ),
.S0( S[3] ), .B( I12 ), .A( I4 ) );
MX2X1 (*
integer library_binding = "gsclib090";
 *)
i_64 ( .Y( n_201 ),
.S0( S[1] ), .B( I18 ), .A( I16 ) );
MX2X1 (*
integer library_binding = "gsclib090";
 *)
i_6 ( .Y( n_123 ),
.S0( S[3] ), .B( I8 ), .A( I0 ) );
MX2X1 (*
integer library_binding = "gsclib090";
 *)
i_69 ( .Y( n_206 ),
.S0( S[1] ), .B( I19 ), .A( I17 ) );
MX2X1 (*
integer library_binding = "gsclib090";
 *)
i_71 ( .Y( n_17 ),
.S0( S[0] ), .B( n_206 ), .A( n_201 ) );
MX2X1 (*
integer library_binding = "gsclib090";
 *)
i_30 ( .Y( O0 ), .S0(
S[4] ), .B( n_236 ), .A( n_14 ) );
MX2X1 (*
integer library_binding = "gsclib090";
 *)
i_18 ( .Y( n_18 ),
.S0( S[0] ), .B( I21 ), .A( I20 ) );

endmodule
