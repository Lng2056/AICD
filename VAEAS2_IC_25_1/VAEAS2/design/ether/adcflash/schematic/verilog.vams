// Verilog-AMS netlist generated by the AMS netlister, version ICOA5.2.51.500.7.
// Cadence Design Systems, Inc.

`include "disciplines.vams"

module adcflash ( out,BASEFX_DIS,SIDDQ,VDD,VSS,bias100_ext,hold,
hold_test,i1000_poly,ibias50_ext,bias100,inm,inm_test,inp,inp_test,ph1,
ph2b,sample,sample_test,FX_BIT );

output [5:0]  out;
input   BASEFX_DIS;
input   SIDDQ;
input   VDD;

input   VSS;
input   bias100_ext;
input   hold;
input   hold_test;

input   i1000_poly;
input   ibias50_ext;
input   bias100;
input
 inm;
input   inm_test;
input   inp;
input   inp_test;
input   ph1;

input   ph2b;
input   sample;
input   sample_test;
output   FX_BIT;

gpdk090_nmos2v #(.ps(21.2u), .m(1 * 2), .as(6p), .l(1u), .pd(10.6u), .ad(3p),
 .w(10u)) (*
integer library_binding = "gpdk090";
integer
passed_mfactor = "m";
 *)
NM0 ( bias100, bias100, VSS, VSS );
gpdk090_nmos2v #(.ps(21.2u), .m(1 * 1), .as(6p), .l(280.0n), .pd(21.2u),
 .ad(6p), .w(10u)) (*
integer library_binding = "gpdk090";
integer
passed_mfactor = "m";
 *)
NM4 ( bias100, EN_1BIT, bias_1bit, VSS );
gpdk090_nmos2v #(.ps(3.2u), .m(1 * 1), .as(600f), .l(280.0n), .pd(3.2u),
 .ad(600f), .w(1u)) (*
integer library_binding = "gpdk090";
integer
passed_mfactor = "m";
 *)
NM2 ( bias_3bit, DIS_CABLE, VSS, VSS );
gpdk090_nmos2v #(.ps(3.2u), .m(1 * 1), .as(600f), .l(280.0n), .pd(3.2u),
 .ad(600f), .w(1u)) (*
integer library_binding = "gpdk090";
integer
passed_mfactor = "m";
 *)
NM1 ( bias_1bit, DIS_FX, VSS, VSS );
gpdk090_nmos2v #(.ps(21.2u), .m(1 * 1), .as(6p), .l(280.0n), .pd(21.2u),
 .ad(6p), .w(10u)) (*
integer library_binding = "gpdk090";
integer
passed_mfactor = "m";
 *)
NM3 ( bias100, EN_3BIT, bias_3bit, VSS );

or2_2x_hv (*
integer library_binding = "ether";
integer cds_net_set
[0:1] = { "DVDD","DVSS" };
integer DVDD = "VDD";
integer DVSS
 = "VSS";
 *)
I40 ( .Y( DIS_FX ), .B( BASEFX_DIS ), .A( SIDDQ ) );
or2_2x_hv (*
integer library_binding = "ether";
integer cds_net_set
[0:1] = { "DVSS","DVDD" };
integer DVSS = "VSS";
integer DVDD
 = "VDD";
 *)
I41 ( .Y( DIS_CABLE ), .B( BASEFX_DISb ), .A( SIDDQ ) );

inv_2x_hv (*
integer library_binding = "ether";
integer cds_net_set
[0:1] = { "DVSS","DVDD" };
integer DVSS = "VSS";
integer DVDD
 = "VDD";
 *)
I38 ( .Y( SIDDQb ), .A( SIDDQ ) );
inv_2x_hv (*
integer library_binding = "ether";
integer cds_net_set
[0:1] = { "DVDD","DVSS" };
integer DVDD = "VDD";
integer DVSS
 = "VSS";
 *)
I39 ( .Y( BASEFX_DISb ), .A( BASEFX_DIS ) );

and2_1x_hv (*
integer library_binding = "ether";
integer cds_net_set
[0:1] = { "DVSS","DVDD" };
integer DVSS = "VSS";
integer DVDD
 = "VDD";
 *)
I37 ( .Y( EN_1BIT ), .B( SIDDQb ), .A( BASEFX_DISb ) );
and2_1x_hv (*
integer library_binding = "ether";
integer cds_net_set
[0:1] = { "DVDD","DVSS" };
integer DVDD = "VDD";
integer DVSS
 = "VSS";
 *)
I42 ( .Y( EN_3BIT ), .B( BASEFX_DIS ), .A( SIDDQb ) );

adc_sample_hold (*
integer library_binding = "ether";
 *)

ADCFLASH_SAMPLE_HOLD ( .SIDDQ( SIDDQ ), .hold_test( hold_test ), .inp(
inp ), .sample_test( sample_test ), .inm_test( inm_test ), .outp(
shoutp ), .sample( sample ), .outm( shoutm ), .VDD( VDD ), .inm( inm ),
.hold( hold ), .bias100( bias100_ext ), .VSS( VSS ), .inp_test(
inp_test ) );

adcflash_comparator_actr (*
integer library_binding = "ether";
 *)
I22
 ( .SIDDQ( DIS_FX ), .inp( shoutp ), .vbias( bias_1bit ), .outp(
FX_BIT ), .outm( net085 ), .VDD( VDD ), .refn( ref5 ), .ph2b( ph2b ),
.ph1( ph1 ), .inn( shoutm ), .refp( ref5 ), .VSS( VSS ) );
adcflash_comparator_actr (*
integer library_binding = "ether";
 *)
I9
 ( .SIDDQ( DIS_CABLE ), .inp( shoutp ), .vbias( bias_3bit ), .outp(
out[0] ), .outm( net86 ), .VDD( VDD ), .refn( ref8 ), .ph2b( ph2b ), .ph1(
ph1 ), .inn( shoutm ), .refp( ref2 ), .VSS( VSS ) );
adcflash_comparator_actr (*
integer library_binding = "ether";
 *)
I8
 ( .SIDDQ( DIS_CABLE ), .inp( shoutp ), .vbias( bias_3bit ), .outp(
out[1] ), .outm( net100 ), .VDD( VDD ), .refn( ref7 ), .ph2b( ph2b ),
.ph1( ph1 ), .inn( shoutm ), .refp( ref3 ), .VSS( VSS ) );
adcflash_comparator_actr (*
integer library_binding = "ether";
 *)
I7
 ( .SIDDQ( DIS_CABLE ), .inp( shoutp ), .vbias( bias_3bit ), .outp(
out[2] ), .outm( net114 ), .VDD( VDD ), .refn( ref6 ), .ph2b( ph2b ),
.ph1( ph1 ), .inn( shoutm ), .refp( ref4 ), .VSS( VSS ) );
adcflash_comparator_actr (*
integer library_binding = "ether";
 *)
I6
 ( .SIDDQ( DIS_CABLE ), .inp( shoutp ), .vbias( bias_3bit ), .outp(
out[3] ), .outm( net44 ), .VDD( VDD ), .refn( ref4 ), .ph2b( ph2b ), .ph1(
ph1 ), .inn( shoutm ), .refp( ref6 ), .VSS( VSS ) );
adcflash_comparator_actr (*
integer library_binding = "ether";
 *)
I5
 ( .SIDDQ( DIS_CABLE ), .inp( shoutp ), .vbias( bias_3bit ), .outp(
out[4] ), .outm( net72 ), .VDD( VDD ), .refn( ref3 ), .ph2b( ph2b ), .ph1(
ph1 ), .inn( shoutm ), .refp( ref7 ), .VSS( VSS ) );
adcflash_comparator_actr (*
integer library_binding = "ether";
 *)
I4
 ( .SIDDQ( DIS_CABLE ), .inp( shoutp ), .vbias( bias_3bit ), .outp(
out[5] ), .outm( net58 ), .VDD( VDD ), .refn( ref2 ), .ph2b( ph2b ), .ph1(
ph1 ), .inn( shoutm ), .refp( ref8 ), .VSS( VSS ) );

adcflash_ref_ladder (*
integer library_binding = "ether";
 *)

ADCFLASH_REF_LADDER ( .INP( shoutp ), .SIDDQ( SIDDQ ), .ref9( net129 ),
.ibias50( ibias50_ext ), .ref7( ref7 ), .ref1( net137 ), .ref8( ref8 ),
.ref10( i1000_poly ), .VDD( VDD ), .ref0( net138 ), .ref3( ref3 ), .ref4(
ref4 ), .INM( shoutm ), .ref2( ref2 ), .VSS( VSS ), .ref6( ref6 ), .ref5(
ref5 ) );

endmodule
