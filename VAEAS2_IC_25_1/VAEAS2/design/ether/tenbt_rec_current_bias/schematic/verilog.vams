// Verilog-AMS netlist generated by the AMS netlister, version ICOA5.2.51.500.7.
// Cadence Design Systems, Inc.

`include "disciplines.vams"

module tenbt_rec_current_bias ( ibias_rext_100u,gnd,vdd,siddq,
vbias_const );

input   ibias_rext_100u;
input   gnd;
input   vdd;
input   siddq;

output   vbias_const;

gpdk090_resnsppoly #(.w(2u), .r(3.249K), .l(16.235u)) (*
integer
library_binding = "gpdk090";
 *)
R2 ( net212, vbias_const, gnd );

gpdk090_nmoscap2v #(.m(1 * 1), .l(7.6u), .w(43.415u)) (*
integer
library_binding = "gpdk090";
integer passed_mfactor = "m";
 *)
C1 (
gnd, vbias_const, gnd, gnd );

gpdk090_nmos2v #(.ps(35.9025u), .m(1 * 4), .as(10.5007p), .l(280.0n),
.pd(23.935u), .ad(7.0005p), .w(23.335u)) (*
integer library_binding
 = "gpdk090";
integer passed_mfactor = "m";
 *)
NM12 ( ibias_rext_100u,
siddq_inv, net212, gnd );
gpdk090_nmos2v #(.ps(3.53u), .m(1 * 1), .as(699f), .l(280.0n), .pd(3.53u),
 .ad(699f), .w(1.165u)) (*
integer library_binding = "gpdk090";

integer passed_mfactor = "m";
 *)
NM8 ( net212, siddq, gnd, gnd );
gpdk090_nmos2v #(.ps(21.2u), .m(1 * 2), .as(6p), .l(2u), .pd(10.6u), .ad(3p),
 .w(10u)) (*
integer library_binding = "gpdk090";
integer
passed_mfactor = "m";
 *)
NM5 ( net212, net212, gnd, gnd );

inv_1X (*
integer library_binding = "ether";
 *)
I2 ( .vss( gnd ), .VDD(
vdd ), .in( siddq ), .out( siddq_inv ) );

endmodule
