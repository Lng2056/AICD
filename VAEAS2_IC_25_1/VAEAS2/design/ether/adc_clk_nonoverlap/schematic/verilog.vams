// Verilog-AMS netlist generated by the AMS netlister, version ICOA5.2.51.500.7.
// Cadence Design Systems, Inc.

`include "disciplines.vams"

module adc_clk_nonoverlap ( hold,hold_f,hold_test,hold_test_f,ph1,ph1b,
ph2,ph2b,sample,sample_f,sample_test,sample_test_f,SIDDQ,TEST_ENABLE,
VDD,VSS,clk_in );

output   hold;
output   hold_f;
output   hold_test;
output
 hold_test_f;
output   ph1;
output   ph1b;
output   ph2;
output
 ph2b;
output   sample;
output   sample_f;
output   sample_test;

output   sample_test_f;
input   SIDDQ;
input   TEST_ENABLE;
input
 VDD;
input   VSS;
input   clk_in;

adc_nandx10 (*
integer library_binding = "ether";
 *)
I231 ( .VDD( VDD ),
.B( SIDDQb ), .OUT( net195 ), .VSS( VSS ), .A( net191 ) );

adc_invertx30 (*
integer library_binding = "ether";
 *)
I220 ( .IN(
net199 ), .VDD( VDD ), .OUT( net127 ), .VSS( VSS ) );
adc_invertx30 (*
integer library_binding = "ether";
 *)
I162 ( .IN(
net195 ), .VDD( VDD ), .OUT( net131 ), .VSS( VSS ) );

adc_invertx300 (*
integer library_binding = "ether";
 *)
I212 ( .IN(
net151 ), .VDD( VDD ), .OUT( ph1 ), .VSS( VSS ) );
adc_invertx300 (*
integer library_binding = "ether";
 *)
I171 ( .IN(
net155 ), .VDD( VDD ), .OUT( ph2b ), .VSS( VSS ) );

adc_invertx100 (*
integer library_binding = "ether";
 *)
I177 ( .IN(
net131 ), .VDD( VDD ), .OUT( ph1b ), .VSS( VSS ) );
adc_invertx100 (*
integer library_binding = "ether";
 *)
I214 ( .IN(
net127 ), .VDD( VDD ), .OUT( net147 ), .VSS( VSS ) );
adc_invertx100 (*
integer library_binding = "ether";
 *)
I163 ( .IN(
net131 ), .VDD( VDD ), .OUT( net151 ), .VSS( VSS ) );
adc_invertx100 (*
integer library_binding = "ether";
 *)
I173 ( .IN(
net147 ), .VDD( VDD ), .OUT( net155 ), .VSS( VSS ) );
adc_invertx100 (*
integer library_binding = "ether";
 *)
I169 ( .IN(
net147 ), .VDD( VDD ), .OUT( ph2 ), .VSS( VSS ) );

adc_invertx10 (*
integer library_binding = "ether";
 *)
I229 ( .IN(
sample_test ), .VDD( VDD ), .OUT( hold_test ), .VSS( VSS ) );
adc_invertx10 (*
integer library_binding = "ether";
 *)
I157 ( .IN(
net235 ), .VDD( VDD ), .OUT( net167 ), .VSS( VSS ) );
adc_invertx10 (*
integer library_binding = "ether";
 *)
I202 ( .IN(
sample_f ), .VDD( VDD ), .OUT( hold_f ), .VSS( VSS ) );
adc_invertx10 (*
integer library_binding = "ether";
 *)
I203 ( .IN(
net217 ), .VDD( VDD ), .OUT( net0195 ), .VSS( VSS ) );
adc_invertx10 (*
integer library_binding = "ether";
 *)
I205 ( .IN(
net212 ), .VDD( VDD ), .OUT( sample_f ), .VSS( VSS ) );
adc_invertx10 (*
integer library_binding = "ether";
 *)
I206 ( .IN(
net0235 ), .VDD( VDD ), .OUT( sample_test_f ), .VSS( VSS ) );
adc_invertx10 (*
integer library_binding = "ether";
 *)
I167 ( .IN(
net227 ), .VDD( VDD ), .OUT( net0199 ), .VSS( VSS ) );
adc_invertx10 (*
integer library_binding = "ether";
 *)
I156 ( .IN(
net231 ), .VDD( VDD ), .OUT( net191 ), .VSS( VSS ) );
adc_invertx10 (*
integer library_binding = "ether";
 *)
I230 ( .IN(
sample_test_f ), .VDD( VDD ), .OUT( hold_test_f ), .VSS( VSS ) );
adc_invertx10 (*
integer library_binding = "ether";
 *)
I219 ( .IN(
net167 ), .VDD( VDD ), .OUT( net199 ), .VSS( VSS ) );
adc_invertx10 (*
integer library_binding = "ether";
 *)
I174 ( .IN(
net0220 ), .VDD( VDD ), .OUT( sample_test ), .VSS( VSS ) );

adc_nandx3 (*
integer library_binding = "ether";
 *)
I227 ( .VDD( VDD ),
.B( SIDDQb ), .OUT( net0220 ), .VSS( VSS ), .A( net0199 ) );
adc_nandx3 (*
integer library_binding = "ether";
 *)
I199 ( .VDD( VDD ),
.B( \100BT_EN  ), .OUT( net212 ), .VSS( VSS ), .A( net266 ) );
adc_nandx3 (*
integer library_binding = "ether";
 *)
I200 ( .VDD( VDD ),
.B( TEST_EN ), .OUT( net217 ), .VSS( VSS ), .A( net274 ) );
adc_nandx3 (*
integer library_binding = "ether";
 *)
I228 ( .VDD( VDD ),
.B( SIDDQb ), .OUT( net0235 ), .VSS( VSS ), .A( net0195 ) );
adc_nandx3 (*
integer library_binding = "ether";
 *)
I164 ( .VDD( VDD ),
.B( \100BT_EN  ), .OUT( net0169 ), .VSS( VSS ), .A( net191 ) );
adc_nandx3 (*
integer library_binding = "ether";
 *)
I165 ( .VDD( VDD ),
.B( TEST_EN ), .OUT( net227 ), .VSS( VSS ), .A( net191 ) );
adc_nandx3 (*
integer library_binding = "ether";
 *)
I151 ( .VDD( VDD ),
.B( net262 ), .OUT( net281 ), .VSS( VSS ), .A( net231 ) );
adc_nandx3 (*
integer library_binding = "ether";
 *)
I150 ( .VDD( VDD ),
.B( net235 ), .OUT( net237 ), .VSS( VSS ), .A( net242 ) );
adc_nandx3 (*
integer library_binding = "ether";
 *)
I148 ( .VDD( VDD ),
.B( SIDDQb ), .OUT( net242 ), .VSS( VSS ), .A( net270 ) );

adc_invertx3 (*
integer library_binding = "ether";
 *)
I139 ( .IN(
TEST_ENABLE ), .VDD( VDD ), .OUT( \100BT_EN  ), .VSS( VSS ) );
adc_invertx3 (*
integer library_binding = "ether";
 *)
I194 ( .IN(
\100BT_EN  ), .VDD( VDD ), .OUT( TEST_EN ), .VSS( VSS ) );
adc_invertx3 (*
integer library_binding = "ether";
 *)
I155 ( .IN(
net282 ), .VDD( VDD ), .OUT( net235 ), .VSS( VSS ) );
adc_invertx3 (*
integer library_binding = "ether";
 *)
I154 ( .IN(
net257 ), .VDD( VDD ), .OUT( net231 ), .VSS( VSS ) );

adc_invertx1 (*
integer library_binding = "ether";
 *)
I225 ( .IN(
net0169 ), .VDD( VDD ), .OUT( net0165 ), .VSS( VSS ) );
adc_invertx1 (*
integer library_binding = "ether";
 *)
I226 ( .IN(
net0165 ), .VDD( VDD ), .OUT( hold ), .VSS( VSS ) );
adc_invertx1 (*
integer library_binding = "ether";
 *)
I149 ( .IN(
net242 ), .VDD( VDD ), .OUT( net262 ), .VSS( VSS ) );
adc_invertx1 (*
integer library_binding = "ether";
 *)
I208 ( .IN(
net191 ), .VDD( VDD ), .OUT( net266 ), .VSS( VSS ) );
adc_invertx1 (*
integer library_binding = "ether";
 *)
I147 ( .IN(
clk_in ), .VDD( VDD ), .OUT( net270 ), .VSS( VSS ) );
adc_invertx1 (*
integer library_binding = "ether";
 *)
I209 ( .IN(
net191 ), .VDD( VDD ), .OUT( net274 ), .VSS( VSS ) );
adc_invertx1 (*
integer library_binding = "ether";
 *)
I166 ( .IN(
net0169 ), .VDD( VDD ), .OUT( sample ), .VSS( VSS ) );
adc_invertx1 (*
integer library_binding = "ether";
 *)
I146 ( .IN(
SIDDQ ), .VDD( VDD ), .OUT( SIDDQb ), .VSS( VSS ) );
adc_invertx1 (*
integer library_binding = "ether";
 *)
I153 ( .IN(
net281 ), .VDD( VDD ), .OUT( net282 ), .VSS( VSS ) );
adc_invertx1 (*
integer library_binding = "ether";
 *)
I152 ( .IN(
net237 ), .VDD( VDD ), .OUT( net257 ), .VSS( VSS ) );

endmodule
