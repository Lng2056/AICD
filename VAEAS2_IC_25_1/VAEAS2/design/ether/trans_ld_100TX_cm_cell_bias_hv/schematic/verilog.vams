// Verilog-AMS netlist generated by the AMS netlister, version ICOA5.2.51.500.7.
// Cadence Design Systems, Inc.

`include "disciplines.vams"

module trans_ld_100TX_cm_cell_bias_hv ( vbias,neg_out,VDD,pos_out,
siddq,switch_vbias,VSS );

input   vbias;
output   neg_out;
input   VDD;
output   pos_out;

input   siddq;
input   switch_vbias;
input   VSS;

gpdk090_nmos2v #(.ps(53.4u), .m(1 * 4), .as(15.75p), .l(280.0n), .pd(35.6u),
 .ad(10.5p), .w(35u)) (*
integer library_binding = "gpdk090";
integer
passed_mfactor = "m";
 *)
NM7 ( net33, siddq, VSS, VSS );
gpdk090_nmos2v #(.ps(58.32u), .m(1 * 10), .as(17.28p), .l(1u), .pd(48.6u),
 .ad(14.4p), .w(48u)) (*
integer library_binding = "gpdk090";
integer
passed_mfactor = "m";
 *)
NM14 ( neg_out, VDD, net19, VSS );
gpdk090_nmos2v #(.ps(29.52u), .m(1 * 10), .as(8.64p), .l(1u), .pd(24.6u),
 .ad(7.2p), .w(24u)) (*
integer library_binding = "gpdk090";
integer
passed_mfactor = "m";
 *)
NM0 ( net33, vbias, VSS, VSS );
gpdk090_nmos2v #(.ps(29.52u), .m(1 * 10), .as(8.64p), .l(1u), .pd(24.6u),
 .ad(7.2p), .w(24u)) (*
integer library_binding = "gpdk090";
integer
passed_mfactor = "m";
 *)
NM1 ( net37, vbias, VSS, VSS );
gpdk090_nmos2v #(.ps(58.32u), .m(1 * 10), .as(17.28p), .l(1u), .pd(48.6u),
 .ad(14.4p), .w(48u)) (*
integer library_binding = "gpdk090";
integer
passed_mfactor = "m";
 *)
NM13 ( pos_out, VDD, net31, VSS );
gpdk090_nmos2v #(.ps(25.96u), .m(1 * 20), .as(7.59p), .l(280.0n), .pd(23.6u),
 .ad(6.9p), .w(23u)) (*
integer library_binding = "gpdk090";
integer
passed_mfactor = "m";
 *)
NM2 ( net31, switch_vbias, net33, VSS );
gpdk090_nmos2v #(.ps(25.96u), .m(1 * 20), .as(7.59p), .l(280.0n), .pd(23.6u),
 .ad(6.9p), .w(23u)) (*
integer library_binding = "gpdk090";
integer
passed_mfactor = "m";
 *)
NM3 ( net19, switch_vbias, net37, VSS );
gpdk090_nmos2v #(.ps(53.4u), .m(1 * 4), .as(15.75p), .l(280.0n), .pd(35.6u),
 .ad(10.5p), .w(35u)) (*
integer library_binding = "gpdk090";
integer
passed_mfactor = "m";
 *)
NM8 ( net37, siddq, VSS, VSS );

endmodule
