// Verilog-AMS netlist generated by the AMS netlister, version ICOA5.2.51.500.7.
// Cadence Design Systems, Inc.

`include "disciplines.vams"

module trans_clkinv_2X ( Vgnd,in,out,Vpwr );

input   Vgnd;
input   in;
output   out;
input   Vpwr;

parameter td=0;
parameter tr=0;
parameter tf=0;

gpdk090_pmos2v #(.ps(6.8u), .m(1 * 1), .as(1.68p), .l(280.0n), .pd(6.8u),
 .ad(1.68p), .w(2.8u)) (*
integer library_binding = "gpdk090";

integer passed_mfactor = "m";
 *)
PM1 ( out, in, Vpwr, Vpwr );

gpdk090_nmos2v #(.ps(4.3u), .m(1 * 1), .as(930f), .l(280.0n), .pd(4.3u),
 .ad(930f), .w(1.55u)) (*
integer library_binding = "gpdk090";

integer passed_mfactor = "m";
 *)
NM1 ( out, in, Vgnd, Vgnd );

endmodule
