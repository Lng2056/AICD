// Verilog-AMS netlist generated by the AMS netlister, version ICOA5.2.51.500.7.
// Cadence Design Systems, Inc.

`include "disciplines.vams"

module adc_therm2bin ( CLK125,THERM,BIN );

input   CLK125;
input [62:0]  THERM;
output [5:0]  BIN;

wire n_1138;
wire [62:0] THERM;
wire n_1580;
wire n_919;
wire n_1321;
wire n_1193;
wire n_1425;
wire n_1612;
wire n_1301;
wire n_1675;
wire n_1640;
wire n_985;
wire n_1485;
wire n_1496;
wire n_1366;
wire n_1214;
wire n_1068;
wire n_915;
wire n_1251;
wire n_964;
wire n_1619;
wire n_1347;
wire n_1224;
wire n_1115;
wire n_1260;
wire n_947;
wire n_858;
wire n_668;
wire n_1297;
wire n_1479;
wire n_1674;
wire n_784;
wire n_976;
wire n_800;
wire n_1503;
wire n_1236;
wire n_885;
wire n_1655;
wire n_1451;
wire n_1059;
wire n_905;
wire n_903;
wire n_1280;
wire n_674;
wire n_1650;
wire n_1390;
wire n_909;
wire n_1645;
wire n_1339;
wire n_1222;
wire n_870;
wire n_1355;
wire n_1411;
wire n_1543;
wire n_1497;
wire n_1618;
wire n_1572;
wire n_1679;
wire n_1690;
wire n_865;
wire n_1399;
wire n_1213;
wire n_1634;
wire n_1194;
wire n_1245;
wire n_1237;
wire n_1457;
wire n_1478;
wire n_1658;
wire n_815;
wire n_938;
wire n_1319;
wire n_1281;
wire n_1533;
wire n_1417;
wire n_1475;
wire n_1001;
wire n_1368;
wire n_1256;
wire n_1501;
wire n_1412;
wire n_1030;
wire n_1199;
wire n_1531;
wire n_1489;
wire n_1064;
wire n_672;
wire n_1624;
wire n_1566;
wire n_1121;
wire n_1692;
wire n_1530;
wire n_1648;
wire n_1701;
wire n_1431;
wire n_1233;
wire n_701;
wire n_834;
wire n_1276;
wire n_1551;
wire n_912;
wire n_1555;
wire n_1414;
wire n_1350;
wire n_1223;
wire n_669;
wire n_1527;
wire n_1410;
wire n_1704;
wire n_920;
wire n_1592;
wire n_1459;
wire n_780;
wire n_1178;
wire n_1184;
wire n_1332;
wire n_1144;
wire n_1191;
wire n_1243;
wire n_1568;
wire n_1118;
wire n_1227;
wire n_1713;
wire n_1230;
wire n_1053;
wire n_1625;
wire n_1700;
wire n_1698;
wire n_1398;
wire n_1333;
wire n_889;
wire n_896;
wire n_1361;
wire n_1608;
wire n_1598;
wire n_1697;
wire n_1177;
wire n_1172;
wire n_1717;
wire n_1235;
wire n_1103;
wire n_1338;
wire n_1379;
wire n_1149;
wire n_1207;
wire n_1075;
wire n_1420;
wire n_1200;
wire n_1715;
wire n_1477;
wire n_973;
wire n_785;
wire n_1210;
wire n_931;
wire n_1113;
wire n_1374;
wire n_750;
wire n_877;
wire n_1523;
wire n_1252;
wire n_836;
wire n_695;
wire n_1474;
wire n_1135;
wire n_1309;
wire n_1505;
wire n_704;
wire n_1336;
wire n_1383;
wire n_1392;
wire n_1529;
wire n_1406;
wire n_696;
wire n_1509;
wire n_1049;
wire n_1684;
wire n_1493;
wire n_1491;
wire n_1691;
wire n_1300;
wire n_895;
wire n_1487;
wire n_1516;
wire n_746;
wire n_1248;
wire n_1678;
wire n_1275;
wire n_1180;
wire n_955;
wire n_1643;
wire n_1065;
wire n_1441;
wire n_953;
wire n_1027;
wire n_1325;
wire n_1274;
wire n_1293;
wire \next_bin[0] ;
wire n_1616;
wire n_841;
wire n_1303;
wire n_925;
wire n_1375;
wire n_1649;
wire n_1147;
wire n_1229;
wire n_1652;
wire n_1532;
wire n_961;
wire n_1295;
wire n_1393;
wire n_928;
wire n_1258;
wire n_1211;
wire n_1080;
wire n_1259;
wire n_1354;
wire n_1165;
wire n_1548;
wire n_1360;
wire n_1061;
wire n_675;
wire n_1601;
wire n_1593;
wire n_1250;
wire n_1556;
wire n_1261;
wire n_1696;
wire n_1483;
wire n_1382;
wire n_1396;
wire n_1239;
wire n_1510;
wire n_1096;
wire n_1323;
wire n_822;
wire n_817;
wire n_1424;
wire n_1644;
wire n_1440;
wire n_939;
wire n_1083;
wire n_881;
wire n_1359;
wire n_968;
wire n_1549;
wire n_664;
wire n_892;
wire n_1416;
wire n_1609;
wire n_886;
wire n_1265;
wire n_1128;
wire n_1377;
wire n_1454;
wire n_1234;
wire n_1636;
wire n_1292;
wire n_1326;
wire n_1511;
wire n_1331;
wire n_1502;
wire n_890;
wire n_1537;
wire n_999;
wire n_852;
wire n_1470;
wire n_1442;
wire n_1448;
wire n_1225;
wire n_1337;
wire n_1429;
wire n_1052;
wire n_988;
wire n_842;
wire n_1240;
wire n_1395;
wire n_1520;
wire n_1358;
wire n_970;
wire n_1290;
wire n_1576;
wire n_1107;
wire n_1514;
wire n_1040;
wire n_1391;
wire n_1415;
wire n_1464;
wire n_835;
wire n_1132;
wire n_1192;
wire n_1156;
wire n_828;
wire n_1628;
wire n_1327;
wire n_1654;
wire n_1219;
wire n_1278;
wire n_1215;
wire n_1262;
wire n_1484;
wire n_1428;
wire n_862;
wire n_1671;
wire n_1389;
wire n_1600;
wire n_703;
wire n_917;
wire n_823;
wire n_1402;
wire n_1403;
wire n_1069;
wire n_744;
wire n_1585;
wire n_1622;
wire n_1689;
wire n_1341;
wire n_1582;
wire n_1443;
wire n_1561;
wire n_1578;
wire n_887;
wire n_1400;
wire n_1002;
wire n_1346;
wire n_1289;
wire n_1641;
wire n_1316;
wire n_1405;
wire n_1287;
wire [5:0] BIN;
wire n_1702;
wire n_1242;
wire n_1563;
wire n_1352;
wire n_1626;
wire n_1631;
wire n_1437;
wire n_1707;
wire n_814;
wire n_1190;
wire n_1334;
wire n_694;
wire n_1449;
wire n_793;
wire n_1285;
wire CLK125;
wire n_1467;
wire n_1246;
wire n_1422;
wire n_1570;
wire n_1317;
wire n_1499;
wire n_900;
wire n_1534;
wire n_1680;
wire n_1310;
wire n_1255;
wire n_1418;
wire n_1045;
wire n_963;
wire n_1500;
wire n_1506;
wire n_1481;
wire n_1342;
wire n_1435;
wire n_958;
wire n_1586;
wire n_1106;
wire n_1564;
wire n_802;
wire n_1651;
wire n_1547;
wire n_1388;
wire n_901;
wire n_1446;
wire n_1007;
wire n_1638;
wire n_1604;
wire n_1186;
wire n_1677;
wire n_1688;
wire n_1461;
wire n_1228;
wire n_1188;
wire n_1515;
wire n_1345;
wire n_1430;
wire n_1711;
wire n_699;
wire n_977;
wire n_662;
wire n_1202;
wire n_1279;
wire n_1021;
wire n_1087;
wire n_907;
wire n_1344;
wire n_1308;
wire n_781;
wire n_1263;
wire n_1012;
wire n_1606;
wire n_747;
wire n_1056;
wire n_1632;
wire n_1122;
wire n_1445;
wire n_926;
wire n_1033;
wire n_1672;
wire n_1535;
wire n_1026;
wire n_1152;
wire n_1614;
wire n_1620;
wire n_1365;
wire n_1512;
wire n_1286;
wire n_1273;
wire n_1367;
wire n_1206;
wire n_782;
wire n_1394;
wire n_1023;
wire n_873;
wire n_1513;
wire n_1136;
wire n_1447;
wire n_1077;
wire n_1432;
wire n_1353;
wire \next_bin[3] ;
wire n_1110;
wire n_1373;
wire n_1031;
wire n_1099;
wire n_1507;
wire n_1155;
wire n_911;
wire n_1588;
wire n_1231;
wire n_791;
wire n_1306;
wire n_1439;
wire n_1277;
wire n_1683;
wire n_1218;
wire n_980;
wire n_1617;
wire n_1084;
wire n_1386;
wire n_1088;
wire n_1318;
wire n_1562;
wire n_1018;
wire n_957;
wire n_944;
wire n_1426;
wire n_1712;
wire n_982;
wire n_816;
wire n_1340;
wire n_1579;
wire n_1141;
wire n_1314;
wire n_1610;
wire n_1627;
wire n_869;
wire n_671;
wire n_1241;
wire n_741;
wire n_1421;
wire n_1423;
wire n_1014;
wire n_945;
wire n_1270;
wire n_1438;
wire n_1458;
wire n_1473;
wire n_1312;
wire n_1257;
wire n_1158;
wire n_1466;
wire n_1574;
wire n_1517;
wire n_863;
wire n_1125;
wire n_1504;
wire n_706;
wire n_1629;
wire n_1706;
wire n_1465;
wire n_1328;
wire n_743;
wire n_1203;
wire n_1469;
wire n_1541;
wire n_1571;
wire n_1176;
wire n_884;
wire n_1197;
wire n_1476;
wire n_1488;
wire n_1685;
wire n_1603;
wire n_801;
wire n_1647;
wire n_1145;
wire n_1189;
wire n_1181;
wire n_1247;
wire n_1436;
wire n_856;
wire n_820;
wire n_1482;
wire n_1315;
wire n_1253;
wire n_1196;
wire n_1642;
wire n_1472;
wire \next_bin[4] ;
wire n_673;
wire n_1296;
wire n_1291;
wire n_1686;
wire n_1288;
wire n_1037;
wire n_1378;
wire n_1536;
wire n_753;
wire n_1204;
wire n_1455;
wire n_1508;
wire n_1404;
wire n_1209;
wire n_1212;
wire n_1372;
wire n_1364;
wire n_1201;
wire n_1385;
wire n_1371;
wire n_1693;
wire n_1307;
wire n_1221;
wire n_1463;
wire n_1710;
wire n_1015;
wire n_1205;
wire n_751;
wire n_1381;
wire n_875;
wire n_1094;
wire n_1232;
wire n_1471;
wire n_1462;
wire n_1351;
wire n_1480;
wire n_1298;
wire n_1695;
wire n_1004;
wire n_1587;
wire n_700;
wire n_1299;
wire n_1324;
wire n_1134;
wire n_930;
wire n_950;
wire n_1456;
wire n_1097;
wire n_1050;
wire n_1596;
wire n_1699;
wire n_1266;
wire n_876;
wire n_866;
wire n_1433;
wire n_1594;
wire n_1102;
wire n_1709;
wire n_1034;
wire n_935;
wire n_1175;
wire n_1272;
wire n_1011;
wire n_1198;
wire n_1282;
wire n_1268;
wire n_1254;
wire n_914;
wire n_1656;
wire n_708;
wire n_1681;
wire n_1238;
wire n_849;
wire n_1058;
wire n_1387;
wire n_778;
wire \next_bin[2] ;
wire n_1116;
wire n_1682;
wire n_989;
wire n_1450;
wire n_1519;
wire n_1078;
wire n_1611;
wire n_1434;
wire n_1185;
wire n_1271;
wire n_1558;
wire n_1694;
wire n_872;
wire n_1305;
wire n_826;
wire n_844;
wire n_1161;
wire n_995;
wire n_1676;
wire n_1526;
wire n_1294;
wire n_1216;
wire n_1595;
wire n_1313;
wire n_861;
wire n_1129;
wire n_1550;
wire n_1244;
wire n_1525;
wire n_974;
wire n_1329;
wire n_1311;
wire n_923;
wire n_1492;
wire n_1602;
wire n_809;
wire n_1335;
wire n_1569;
wire n_1524;
wire n_996;
wire n_969;
wire n_1267;
wire n_1220;
wire n_1046;
wire n_1369;
wire n_1560;
wire n_1397;
wire n_1590;
wire n_698;
wire n_1409;
wire n_1546;
wire n_1521;
wire n_1320;
wire n_855;
wire n_1538;
wire n_936;
wire n_993;
wire n_1494;
wire n_1072;
wire n_1380;
wire n_1544;
wire n_1384;
wire n_983;
wire n_1427;
wire n_748;
wire n_1486;
wire n_1109;
wire n_1401;
wire n_1269;
wire n_1703;
wire n_992;
wire n_1217;
wire n_1452;
wire n_1490;
wire n_1714;
wire n_1635;
wire n_1020;
wire n_1673;
wire n_1208;
wire \next_bin[1] ;
wire n_1444;
wire n_1716;
wire n_1460;
wire n_1419;
wire n_1187;
wire n_1718;
wire n_1164;
wire n_868;
wire n_1687;
wire n_1091;
wire n_1408;
wire n_1302;
wire n_1518;
wire n_1090;
wire n_667;
wire n_1348;
wire n_1495;
wire n_1264;
wire n_1249;
wire n_1584;
wire n_1042;
wire n_1407;
wire n_1322;
wire n_1528;
wire n_1283;
wire n_1554;
wire n_1370;
wire n_1498;
wire n_1349;
wire n_1705;
wire n_1577;
wire n_1522;
wire n_1195;
wire n_1330;
wire n_932;
wire n_1413;
wire n_1284;
wire n_665;
wire n_754;
wire n_1552;
wire n_1008;
wire n_878;
wire n_1343;
wire n_1226;
wire n_1304;
wire n_966;
wire n_1453;
wire n_1633;
wire n_1159;
wire n_1708;
wire n_1468;
wire n_859;
wire n_1071;
wire n_1039;
wire n_942;
wire n_752;
wire n_1376;

INVX1 (*
integer library_binding = "gsclib090";
 *)
i_2107 ( .Y(
n_1718 ), .A( n_1656 ) );
INVX1 (*
integer library_binding = "gsclib090";
 *)
i_2106 ( .Y(
n_1717 ), .A( n_1178 ) );
INVX1 (*
integer library_binding = "gsclib090";
 *)
i_2105 ( .Y(
n_1716 ), .A( n_1180 ) );
INVX1 (*
integer library_binding = "gsclib090";
 *)
i_2104 ( .Y(
n_1715 ), .A( n_1190 ) );
INVX1 (*
integer library_binding = "gsclib090";
 *)
i_2103 ( .Y(
n_1714 ), .A( n_1193 ) );
INVX1 (*
integer library_binding = "gsclib090";
 *)
i_2102 ( .Y(
n_1713 ), .A( n_1165 ) );
INVX1 (*
integer library_binding = "gsclib090";
 *)
i_2101 ( .Y(
n_1712 ), .A( n_1164 ) );
INVX1 (*
integer library_binding = "gsclib090";
 *)
i_2099 ( .Y(
n_1711 ), .A( n_1202 ) );
INVX1 (*
integer library_binding = "gsclib090";
 *)
i_2098 ( .Y(
n_1710 ), .A( n_1205 ) );
INVX1 (*
integer library_binding = "gsclib090";
 *)
i_2097 ( .Y(
n_1709 ), .A( n_932 ) );
INVX1 (*
integer library_binding = "gsclib090";
 *)
i_2096 ( .Y(
n_1708 ), .A( n_1214 ) );
INVX1 (*
integer library_binding = "gsclib090";
 *)
i_2095 ( .Y(
n_1707 ), .A( n_1217 ) );
INVX1 (*
integer library_binding = "gsclib090";
 *)
i_2094 ( .Y(
n_1706 ), .A( n_1220 ) );
INVX1 (*
integer library_binding = "gsclib090";
 *)
i_2093 ( .Y(
n_1705 ), .A( n_1226 ) );
INVX1 (*
integer library_binding = "gsclib090";
 *)
i_2092 ( .Y(
n_1704 ), .A( n_1229 ) );
INVX1 (*
integer library_binding = "gsclib090";
 *)
i_2091 ( .Y(
n_1703 ), .A( n_970 ) );
INVX1 (*
integer library_binding = "gsclib090";
 *)
i_2090 ( .Y(
n_1702 ), .A( n_1238 ) );
INVX1 (*
integer library_binding = "gsclib090";
 *)
i_2089 ( .Y(
n_1701 ), .A( n_989 ) );
INVX1 (*
integer library_binding = "gsclib090";
 *)
i_2088 ( .Y(
n_1700 ), .A( n_1244 ) );
INVX1 (*
integer library_binding = "gsclib090";
 *)
i_2087 ( .Y(
n_1699 ), .A( n_1250 ) );
INVX1 (*
integer library_binding = "gsclib090";
 *)
i_2086 ( .Y(
n_1698 ), .A( n_1008 ) );
INVX1 (*
integer library_binding = "gsclib090";
 *)
i_2085 ( .Y(
n_1697 ), .A( n_1256 ) );
INVX1 (*
integer library_binding = "gsclib090";
 *)
i_2084 ( .Y(
n_1696 ), .A( n_1544 ) );
INVX1 (*
integer library_binding = "gsclib090";
 *)
i_2083 ( .Y(
n_1695 ), .A( n_1358 ) );
INVX1 (*
integer library_binding = "gsclib090";
 *)
i_2082 ( .Y(
n_1694 ), .A( n_1352 ) );
INVX1 (*
integer library_binding = "gsclib090";
 *)
i_2081 ( .Y(
n_1693 ), .A( n_1552 ) );
INVX1 (*
integer library_binding = "gsclib090";
 *)
i_2080 ( .Y(
n_1692 ), .A( n_1346 ) );
INVX1 (*
integer library_binding = "gsclib090";
 *)
i_2079 ( .Y(
n_1691 ), .A( n_1349 ) );
INVX1 (*
integer library_binding = "gsclib090";
 *)
i_2078 ( .Y(
n_1690 ), .A( n_1340 ) );
INVX1 (*
integer library_binding = "gsclib090";
 *)
i_2077 ( .Y(
n_1689 ), .A( n_1334 ) );
INVX1 (*
integer library_binding = "gsclib090";
 *)
i_2076 ( .Y(
n_1688 ), .A( n_1316 ) );
INVX1 (*
integer library_binding = "gsclib090";
 *)
i_2075 ( .Y(
n_1687 ), .A( n_1310 ) );
INVX1 (*
integer library_binding = "gsclib090";
 *)
i_2074 ( .Y(
n_1686 ), .A( n_1328 ) );
INVX1 (*
integer library_binding = "gsclib090";
 *)
i_2073 ( .Y(
n_1685 ), .A( n_1304 ) );
INVX1 (*
integer library_binding = "gsclib090";
 *)
i_2072 ( .Y(
n_1684 ), .A( n_1570 ) );
INVX1 (*
integer library_binding = "gsclib090";
 *)
i_2071 ( .Y(
n_1683 ), .A( n_1103 ) );
INVX1 (*
integer library_binding = "gsclib090";
 *)
i_2070 ( .Y(
n_1682 ), .A( n_1322 ) );
INVX1 (*
integer library_binding = "gsclib090";
 *)
i_2069 ( .Y(
n_1681 ), .A( n_1084 ) );
INVX1 (*
integer library_binding = "gsclib090";
 *)
i_2068 ( .Y(
n_1680 ), .A( n_1298 ) );
INVX1 (*
integer library_binding = "gsclib090";
 *)
i_2067 ( .Y(
n_1679 ), .A( n_1262 ) );
INVX1 (*
integer library_binding = "gsclib090";
 *)
i_2066 ( .Y(
n_1678 ), .A( n_1027 ) );
INVX1 (*
integer library_binding = "gsclib090";
 *)
i_2065 ( .Y(
n_1677 ), .A( n_1292 ) );
INVX1 (*
integer library_binding = "gsclib090";
 *)
i_2064 ( .Y(
n_1676 ), .A( n_1268 ) );
INVX1 (*
integer library_binding = "gsclib090";
 *)
i_2063 ( .Y(
n_1675 ), .A( n_1065 ) );
INVX1 (*
integer library_binding = "gsclib090";
 *)
i_2062 ( .Y(
n_1674 ), .A( n_1286 ) );
INVX1 (*
integer library_binding = "gsclib090";
 *)
i_2061 ( .Y(
n_1673 ), .A( n_1274 ) );
INVX1 (*
integer library_binding = "gsclib090";
 *)
i_2060 ( .Y(
n_1672 ), .A( n_1046 ) );
INVX1 (*
integer library_binding = "gsclib090";
 *)
i_2059 ( .Y(
n_1671 ), .A( n_1280 ) );

DFFX1 (*
integer library_binding = "gsclib090";
 *)
BIN_reg_5 ( .QN(
net4973 ), .D( n_1658 ), .CK( CLK125 ), .Q( BIN[5] ) );
DFFX1 (*
integer library_binding = "gsclib090";
 *)
BIN_reg_4 ( .QN(
net4977 ), .D( \next_bin[4]  ), .CK( CLK125 ), .Q( BIN[4] ) );
DFFX1 (*
integer library_binding = "gsclib090";
 *)
BIN_reg_3 ( .QN(
net4981 ), .D( \next_bin[3]  ), .CK( CLK125 ), .Q( BIN[3] ) );
DFFX1 (*
integer library_binding = "gsclib090";
 *)
BIN_reg_2 ( .QN(
net4985 ), .D( \next_bin[2]  ), .CK( CLK125 ), .Q( BIN[2] ) );
DFFX1 (*
integer library_binding = "gsclib090";
 *)
BIN_reg_1 ( .QN(
net4989 ), .D( \next_bin[1]  ), .CK( CLK125 ), .Q( BIN[1] ) );
DFFX1 (*
integer library_binding = "gsclib090";
 *)
BIN_reg_0 ( .QN(
net4993 ), .D( \next_bin[0]  ), .CK( CLK125 ), .Q( BIN[0] ) );

OAI33X1 (*
integer library_binding = "gsclib090";
 *)
i_129 ( .A0(
n_901 ), .B2( n_896 ), .A1( n_900 ), .B0( n_1187 ), .Y( n_1652 ), .A2(
n_1193 ), .B1( n_1184 ) );
OAI33X1 (*
integer library_binding = "gsclib090";
 *)
i_150 ( .A0(
n_1217 ), .B2( n_932 ), .A1( n_1214 ), .B0( n_1208 ), .Y( n_1638 ), .A2(
n_935 ), .B1( n_1205 ) );
OAI33X1 (*
integer library_binding = "gsclib090";
 *)
i_174 ( .A0(
n_1241 ), .B2( n_970 ), .A1( n_1238 ), .B0( n_1232 ), .Y( n_1622 ), .A2(
n_973 ), .B1( n_1229 ) );
OAI33X1 (*
integer library_binding = "gsclib090";
 *)
i_186 ( .A0(
n_1253 ), .B2( n_989 ), .A1( n_1250 ), .B0( n_1244 ), .Y( n_1614 ), .A2(
n_992 ), .B1( n_1241 ) );
OAI33X1 (*
integer library_binding = "gsclib090";
 *)
i_198 ( .A0(
n_1265 ), .B2( n_1008 ), .A1( n_1262 ), .B0( n_1256 ), .Y( n_1606 ), .A2(
n_1011 ), .B1( n_1253 ) );
OAI33X1 (*
integer library_binding = "gsclib090";
 *)
i_210 ( .A0(
n_1277 ), .B2( n_1027 ), .A1( n_1274 ), .B0( n_1268 ), .Y( n_1598 ), .A2(
n_1030 ), .B1( n_1265 ) );
OAI33X1 (*
integer library_binding = "gsclib090";
 *)
i_222 ( .A0(
n_1289 ), .B2( n_1046 ), .A1( n_1286 ), .B0( n_1280 ), .Y( n_1590 ), .A2(
n_1049 ), .B1( n_1277 ) );
OAI33X1 (*
integer library_binding = "gsclib090";
 *)
i_234 ( .A0(
n_1301 ), .B2( n_1065 ), .A1( n_1298 ), .B0( n_1292 ), .Y( n_1582 ), .A2(
n_1068 ), .B1( n_1289 ) );
OAI33X1 (*
integer library_binding = "gsclib090";
 *)
i_246 ( .A0(
n_1313 ), .B2( n_1084 ), .A1( n_1310 ), .B0( n_1304 ), .Y( n_1574 ), .A2(
n_1087 ), .B1( n_1301 ) );
OAI33X1 (*
integer library_binding = "gsclib090";
 *)
i_258 ( .A0(
n_1322 ), .B2( n_1103 ), .A1( n_1325 ), .B0( n_1316 ), .Y( n_1566 ), .A2(
n_1106 ), .B1( n_1313 ) );
OAI33X1 (*
integer library_binding = "gsclib090";
 *)
i_270 ( .A0(
n_1334 ), .B2( n_1122 ), .A1( n_1337 ), .B0( n_1325 ), .Y( n_1558 ), .A2(
n_1125 ), .B1( n_1328 ) );
OAI33X1 (*
integer library_binding = "gsclib090";
 *)
i_279 ( .A0(
n_1343 ), .B2( n_1136 ), .A1( n_1346 ), .B0( n_1334 ), .Y( n_1552 ), .A2(
n_1138 ), .B1( n_1337 ) );

AOI22X1 (*
integer library_binding = "gsclib090";
 *)
i_123 ( .A0(
n_890 ), .A1( n_889 ), .B0( n_1184 ), .Y( n_1656 ), .B1( n_887 ) );
AOI22X1 (*
integer library_binding = "gsclib090";
 *)
i_740 ( .A0(
THERM[61] ), .A1( THERM[62] ), .B0( n_1541 ), .Y( n_1358 ), .B1(
n_1538 ) );

NOR3X1 (*
integer library_binding = "gsclib090";
 *)
i_119 ( .C( n_784 ),
.Y( n_782 ), .B( n_1640 ), .A( n_1642 ) );

OAI21X1 (*
integer library_binding = "gsclib090";
 *)
i_153 ( .A0(
n_1217 ), .A1( n_939 ), .B0( n_938 ), .Y( n_1636 ) );
OAI21X1 (*
integer library_binding = "gsclib090";
 *)
i_177 ( .A0(
n_1241 ), .A1( n_977 ), .B0( n_976 ), .Y( n_1620 ) );
OAI21X1 (*
integer library_binding = "gsclib090";
 *)
i_189 ( .A0(
n_1253 ), .A1( n_996 ), .B0( n_995 ), .Y( n_1612 ) );
OAI21X1 (*
integer library_binding = "gsclib090";
 *)
i_201 ( .A0(
n_1265 ), .A1( n_1015 ), .B0( n_1014 ), .Y( n_1604 ) );
OAI21X1 (*
integer library_binding = "gsclib090";
 *)
i_213 ( .A0(
n_1277 ), .A1( n_1034 ), .B0( n_1033 ), .Y( n_1596 ) );
OAI21X1 (*
integer library_binding = "gsclib090";
 *)
i_225 ( .A0(
n_1289 ), .A1( n_1053 ), .B0( n_1052 ), .Y( n_1588 ) );
OAI21X1 (*
integer library_binding = "gsclib090";
 *)
i_237 ( .A0(
n_1301 ), .A1( n_1072 ), .B0( n_1071 ), .Y( n_1580 ) );
OAI21X1 (*
integer library_binding = "gsclib090";
 *)
i_249 ( .A0(
n_1313 ), .A1( n_1091 ), .B0( n_1090 ), .Y( n_1572 ) );
OAI21X1 (*
integer library_binding = "gsclib090";
 *)
i_261 ( .A0(
n_1325 ), .A1( n_1110 ), .B0( n_1109 ), .Y( n_1564 ) );
OAI21X1 (*
integer library_binding = "gsclib090";
 *)
i_273 ( .A0(
n_1337 ), .A1( n_1129 ), .B0( n_1128 ), .Y( n_1556 ) );
OAI21X1 (*
integer library_binding = "gsclib090";
 *)
i_282 ( .A0(
n_1340 ), .A1( n_1141 ), .B0( n_1551 ), .Y( n_1550 ) );
OAI21X1 (*
integer library_binding = "gsclib090";
 *)
i_288 ( .A0(
n_1346 ), .A1( n_1149 ), .B0( n_1547 ), .Y( n_1546 ) );
OAI21X1 (*
integer library_binding = "gsclib090";
 *)
i_291 ( .A0(
n_1158 ), .A1( n_1156 ), .B0( n_1155 ), .Y( n_1544 ) );
OAI21X1 (*
integer library_binding = "gsclib090";
 *)
i_250 ( .A0(
THERM[62] ), .A1( THERM[61] ), .B0( THERM[60] ), .Y( n_694 ) );
OAI21X1 (*
integer library_binding = "gsclib090";
 *)
i_248 ( .A0(
THERM[59] ), .A1( THERM[60] ), .B0( THERM[61] ), .Y( n_695 ) );
OAI21X1 (*
integer library_binding = "gsclib090";
 *)
i_247 ( .A0(
n_1535 ), .A1( n_1538 ), .B0( n_1541 ), .Y( n_696 ) );
OAI21X1 (*
integer library_binding = "gsclib090";
 *)
i_100 ( .A0(
THERM[1] ), .A1( THERM[2] ), .B0( THERM[0] ), .Y( n_800 ) );
OAI21X1 (*
integer library_binding = "gsclib090";
 *)
i_99 ( .A0(
n_1364 ), .A1( n_1367 ), .B0( n_1360 ), .Y( n_801 ) );
OAI21X1 (*
integer library_binding = "gsclib090";
 *)
i_59 ( .A0(
n_1187 ), .A1( n_885 ), .B0( n_1656 ), .Y( n_841 ) );

AOI21X1 (*
integer library_binding = "gsclib090";
 *)
i_285 ( .A0(
n_1135 ), .A1( n_1145 ), .B0( n_1549 ), .Y( n_1548 ) );
AOI21X1 (*
integer library_binding = "gsclib090";
 *)
i_294 ( .A0(
n_1352 ), .A1( n_1145 ), .B0( n_1159 ), .Y( n_1543 ) );
AOI21X1 (*
integer library_binding = "gsclib090";
 *)
i_1040 ( .A0(
n_1364 ), .A1( n_1713 ), .B0( n_1360 ), .Y( n_1178 ) );
AOI21X1 (*
integer library_binding = "gsclib090";
 *)
i_45 ( .A0(
n_1352 ), .A1( n_1695 ), .B0( n_1712 ), .Y( n_855 ) );

OR2X1 (*
integer library_binding = "gsclib090";
 *)
i_19847 ( .Y(
n_1645 ), .B( n_920 ), .A( n_1205 ) );
OR2X1 (*
integer library_binding = "gsclib090";
 *)
i_19783 ( .Y(
n_1629 ), .B( n_958 ), .A( n_1229 ) );
OR2X1 (*
integer library_binding = "gsclib090";
 *)
i_15445 ( .Y(
n_1158 ), .B( n_1695 ), .A( n_1355 ) );
OR2X1 (*
integer library_binding = "gsclib090";
 *)
i_278 ( .Y( n_675 ),
.B( n_1596 ), .A( n_1598 ) );
OR2X1 (*
integer library_binding = "gsclib090";
 *)
i_161 ( .Y( n_753 ),
.B( n_1624 ), .A( n_1626 ) );
OR2X1 (*
integer library_binding = "gsclib090";
 *)
i_11 ( .Y( n_877 ),
.B( n_881 ), .A( n_878 ) );

OR4X1 (*
integer library_binding = "gsclib090";
 *)
i_35 ( .D( n_791 ),
.C( n_785 ), .Y( \next_bin[3]  ), .B( n_778 ), .A( n_741 ) );
OR4X1 (*
integer library_binding = "gsclib090";
 *)
i_3101 ( .D( n_849 ),
.C( n_842 ), .Y( \next_bin[1]  ), .B( n_835 ), .A( n_828 ) );
OR4X1 (*
integer library_binding = "gsclib090";
 *)
i_3427 ( .D( n_877 ),
.C( n_870 ), .Y( \next_bin[0]  ), .B( n_863 ), .A( n_856 ) );
OR4X1 (*
integer library_binding = "gsclib090";
 *)
i_19455 ( .D(
n_1152 ), .C( n_1136 ), .Y( n_1547 ), .B( n_1355 ), .A( n_1352 ) );
OR4X1 (*
integer library_binding = "gsclib090";
 *)
i_77 ( .D( n_1556 ),
.C( n_1554 ), .Y( n_823 ), .B( n_1558 ), .A( n_1568 ) );
OR4X1 (*
integer library_binding = "gsclib090";
 *)
i_83 ( .D( n_1584 ),
.C( n_1586 ), .Y( n_817 ), .B( n_1588 ), .A( n_1590 ) );
OR4X1 (*
integer library_binding = "gsclib090";
 *)
i_65 ( .D( n_836 ),
.C( n_841 ), .Y( n_835 ), .B( n_1648 ), .A( n_1650 ) );
OR4X1 (*
integer library_binding = "gsclib090";
 *)
i_64 ( .D( n_1640 ),
.C( n_1642 ), .Y( n_836 ), .B( n_1632 ), .A( n_1634 ) );
OR4X1 (*
integer library_binding = "gsclib090";
 *)
i_8 ( .D( n_1552 ),
.C( n_1556 ), .Y( n_878 ), .B( n_1560 ), .A( n_1564 ) );

AND2X1 (*
integer library_binding = "gsclib090";
 *)
i_3 ( .Y( n_1658 ),
.B( n_1177 ), .A( n_1175 ) );
AND2X1 (*
integer library_binding = "gsclib090";
 *)
i_10441 ( .Y(
n_1159 ), .B( n_1695 ), .A( n_1355 ) );
AND2X1 (*
integer library_binding = "gsclib090";
 *)
i_242 ( .Y( n_699 ),
.B( n_701 ), .A( n_700 ) );
AND2X1 (*
integer library_binding = "gsclib090";
 *)
i_14868 ( .Y(
n_905 ), .B( n_1714 ), .A( n_1190 ) );

NAND4X1 (*
integer library_binding = "gsclib090";
 *)
i_19887 ( .D(
n_895 ), .C( n_1184 ), .Y( n_1655 ), .B( n_1717 ), .A( n_1180 ) );
NAND4X1 (*
integer library_binding = "gsclib090";
 *)
i_19871 ( .D(
n_905 ), .C( n_907 ), .Y( n_1651 ), .B( n_1184 ), .A( n_1187 ) );
NAND4X1 (*
integer library_binding = "gsclib090";
 *)
i_19863 ( .D(
n_911 ), .C( n_912 ), .Y( n_1649 ), .B( n_1187 ), .A( n_1190 ) );
NAND4X1 (*
integer library_binding = "gsclib090";
 *)
i_19855 ( .D(
n_917 ), .C( n_1196 ), .Y( n_1647 ), .B( n_1190 ), .A( n_1193 ) );
NAND4X1 (*
integer library_binding = "gsclib090";
 *)
i_19839 ( .D(
n_925 ), .C( n_926 ), .Y( n_1643 ), .B( n_1196 ), .A( n_1199 ) );
NAND4X1 (*
integer library_binding = "gsclib090";
 *)
i_19831 ( .D(
n_930 ), .C( n_931 ), .Y( n_1641 ), .B( n_1199 ), .A( n_1202 ) );
NAND4X1 (*
integer library_binding = "gsclib090";
 *)
i_19807 ( .D(
n_944 ), .C( n_945 ), .Y( n_1635 ), .B( n_1208 ), .A( n_1211 ) );
NAND4X1 (*
integer library_binding = "gsclib090";
 *)
i_19799 ( .D(
n_1709 ), .C( n_1706 ), .Y( n_1633 ), .B( n_950 ), .A( n_1217 ) );
NAND4X1 (*
integer library_binding = "gsclib090";
 *)
i_19791 ( .D(
n_1220 ), .C( n_955 ), .Y( n_1631 ), .B( n_1214 ), .A( n_1217 ) );
NAND4X1 (*
integer library_binding = "gsclib090";
 *)
i_19775 ( .D(
n_963 ), .C( n_964 ), .Y( n_1627 ), .B( n_1220 ), .A( n_1223 ) );
NAND4X1 (*
integer library_binding = "gsclib090";
 *)
i_19767 ( .D(
n_968 ), .C( n_969 ), .Y( n_1625 ), .B( n_1223 ), .A( n_1226 ) );
NAND4X1 (*
integer library_binding = "gsclib090";
 *)
i_19743 ( .D(
n_982 ), .C( n_983 ), .Y( n_1619 ), .B( n_1232 ), .A( n_1235 ) );
NAND4X1 (*
integer library_binding = "gsclib090";
 *)
i_19735 ( .D(
n_1703 ), .C( n_1700 ), .Y( n_1617 ), .B( n_988 ), .A( n_1241 ) );
NAND4X1 (*
integer library_binding = "gsclib090";
 *)
i_19711 ( .D(
n_1001 ), .C( n_1002 ), .Y( n_1611 ), .B( n_1244 ), .A( n_1247 ) );
NAND4X1 (*
integer library_binding = "gsclib090";
 *)
i_19703 ( .D(
n_1701 ), .C( n_1697 ), .Y( n_1609 ), .B( n_1007 ), .A( n_1253 ) );
NAND4X1 (*
integer library_binding = "gsclib090";
 *)
i_19679 ( .D(
n_1020 ), .C( n_1021 ), .Y( n_1603 ), .B( n_1256 ), .A( n_1259 ) );
NAND4X1 (*
integer library_binding = "gsclib090";
 *)
i_19671 ( .D(
n_1698 ), .C( n_1676 ), .Y( n_1601 ), .B( n_1026 ), .A( n_1265 ) );
NAND4X1 (*
integer library_binding = "gsclib090";
 *)
i_19647 ( .D(
n_1039 ), .C( n_1040 ), .Y( n_1595 ), .B( n_1268 ), .A( n_1271 ) );
NAND4X1 (*
integer library_binding = "gsclib090";
 *)
i_19639 ( .D(
n_1678 ), .C( n_1671 ), .Y( n_1593 ), .B( n_1045 ), .A( n_1277 ) );
NAND4X1 (*
integer library_binding = "gsclib090";
 *)
i_19615 ( .D(
n_1058 ), .C( n_1059 ), .Y( n_1587 ), .B( n_1280 ), .A( n_1283 ) );
NAND4X1 (*
integer library_binding = "gsclib090";
 *)
i_19607 ( .D(
n_1672 ), .C( n_1677 ), .Y( n_1585 ), .B( n_1064 ), .A( n_1289 ) );
NAND4X1 (*
integer library_binding = "gsclib090";
 *)
i_19583 ( .D(
n_1077 ), .C( n_1078 ), .Y( n_1579 ), .B( n_1292 ), .A( n_1295 ) );
NAND4X1 (*
integer library_binding = "gsclib090";
 *)
i_19575 ( .D(
n_1675 ), .C( n_1685 ), .Y( n_1577 ), .B( n_1083 ), .A( n_1301 ) );
NAND4X1 (*
integer library_binding = "gsclib090";
 *)
i_19551 ( .D(
n_1096 ), .C( n_1097 ), .Y( n_1571 ), .B( n_1304 ), .A( n_1307 ) );
NAND4X1 (*
integer library_binding = "gsclib090";
 *)
i_19543 ( .D(
n_1681 ), .C( n_1688 ), .Y( n_1569 ), .B( n_1102 ), .A( n_1313 ) );
NAND4X1 (*
integer library_binding = "gsclib090";
 *)
i_19519 ( .D(
n_1115 ), .C( n_1116 ), .Y( n_1563 ), .B( n_1316 ), .A( n_1319 ) );
NAND4X1 (*
integer library_binding = "gsclib090";
 *)
i_19511 ( .D(
n_1683 ), .C( n_1686 ), .Y( n_1561 ), .B( n_1121 ), .A( n_1325 ) );
NAND4X1 (*
integer library_binding = "gsclib090";
 *)
i_19487 ( .D(
n_1134 ), .C( n_1135 ), .Y( n_1555 ), .B( n_1328 ), .A( n_1331 ) );
NAND4X1 (*
integer library_binding = "gsclib090";
 *)
i_19471 ( .D(
n_1144 ), .C( n_1340 ), .Y( n_1551 ), .B( n_1334 ), .A( n_1337 ) );
NAND4X1 (*
integer library_binding = "gsclib090";
 *)
i_14 ( .D(
n_1349 ), .C( n_1358 ), .Y( n_1161 ), .B( n_1355 ), .A( n_1352 ) );
NAND4X1 (*
integer library_binding = "gsclib090";
 *)
i_297 ( .D(
n_668 ), .C( n_667 ), .Y( n_662 ), .B( n_665 ), .A( n_664 ) );
NAND4X1 (*
integer library_binding = "gsclib090";
 *)
i_235 ( .D(
n_1548 ), .C( n_708 ), .Y( n_704 ), .B( n_1543 ), .A( n_706 ) );
NAND4X1 (*
integer library_binding = "gsclib090";
 *)
i_17446 ( .D(
n_1694 ), .C( n_1349 ), .Y( n_1156 ), .B( n_1343 ), .A( n_1346 ) );
NAND4X1 (*
integer library_binding = "gsclib090";
 *)
i_17462 ( .D(
n_1692 ), .C( n_1343 ), .Y( n_1147 ), .B( n_1337 ), .A( n_1340 ) );
NAND4X1 (*
integer library_binding = "gsclib090";
 *)
i_17478 ( .D(
n_1690 ), .C( n_1337 ), .Y( n_1138 ), .B( n_1331 ), .A( n_1334 ) );
NAND4X1 (*
integer library_binding = "gsclib090";
 *)
i_17494 ( .D(
n_1689 ), .C( n_1328 ), .Y( n_1129 ), .B( n_1331 ), .A( n_1325 ) );
NAND4X1 (*
integer library_binding = "gsclib090";
 *)
i_17526 ( .D(
n_1682 ), .C( n_1316 ), .Y( n_1110 ), .B( n_1319 ), .A( n_1313 ) );
NAND4X1 (*
integer library_binding = "gsclib090";
 *)
i_17558 ( .D(
n_1687 ), .C( n_1304 ), .Y( n_1091 ), .B( n_1301 ), .A( n_1307 ) );
NAND4X1 (*
integer library_binding = "gsclib090";
 *)
i_17590 ( .D(
n_1680 ), .C( n_1292 ), .Y( n_1072 ), .B( n_1289 ), .A( n_1295 ) );
NAND4X1 (*
integer library_binding = "gsclib090";
 *)
i_17622 ( .D(
n_1674 ), .C( n_1280 ), .Y( n_1053 ), .B( n_1277 ), .A( n_1283 ) );
NAND4X1 (*
integer library_binding = "gsclib090";
 *)
i_280 ( .D(
n_1042 ), .C( n_1593 ), .Y( n_674 ), .B( n_1037 ), .A( n_1595 ) );
NAND4X1 (*
integer library_binding = "gsclib090";
 *)
i_244 ( .D(
n_699 ), .C( n_703 ), .Y( n_698 ), .B( n_1132 ), .A( n_1555 ) );
NAND4X1 (*
integer library_binding = "gsclib090";
 *)
i_179 ( .D(
n_747 ), .C( n_746 ), .Y( n_741 ), .B( n_744 ), .A( n_743 ) );
NAND4X1 (*
integer library_binding = "gsclib090";
 *)
i_160 ( .D(
n_1629 ), .C( n_957 ), .Y( n_754 ), .B( n_953 ), .A( n_1631 ) );
NAND4X1 (*
integer library_binding = "gsclib090";
 *)
i_117 ( .D(
n_1645 ), .C( n_919 ), .Y( n_784 ), .B( n_915 ), .A( n_1647 ) );
NAND4X1 (*
integer library_binding = "gsclib090";
 *)
i_116 ( .D(
n_1684 ), .C( n_665 ), .Y( n_785 ), .B( n_667 ), .A( n_668 ) );
NAND4X1 (*
integer library_binding = "gsclib090";
 *)
i_109 ( .D(
n_708 ), .C( n_1543 ), .Y( n_791 ), .B( n_793 ), .A( n_1548 ) );
NAND4X1 (*
integer library_binding = "gsclib090";
 *)
i_98 ( .D( n_751 ),
.C( n_750 ), .Y( n_802 ), .B( n_744 ), .A( n_743 ) );
NAND4X1 (*
integer library_binding = "gsclib090";
 *)
i_91 ( .D( n_815 ),
.C( n_814 ), .Y( n_809 ), .B( n_781 ), .A( n_780 ) );
NAND4X1 (*
integer library_binding = "gsclib090";
 *)
i_72 ( .D( n_834 ),
.C( n_750 ), .Y( n_828 ), .B( n_746 ), .A( n_743 ) );
NAND4X1 (*
integer library_binding = "gsclib090";
 *)
i_58 ( .D( n_844 ),
.C( n_664 ), .Y( n_842 ), .B( n_667 ), .A( n_671 ) );
NAND4X1 (*
integer library_binding = "gsclib090";
 *)
i_51 ( .D( n_701 ),
.C( n_855 ), .Y( n_849 ), .B( n_708 ), .A( n_852 ) );
NAND4X1 (*
integer library_binding = "gsclib090";
 *)
i_44 ( .D( n_858 ),
.C( n_862 ), .Y( n_856 ), .B( n_861 ), .A( n_859 ) );
NAND4X1 (*
integer library_binding = "gsclib090";
 *)
i_36 ( .D( n_869 ),
.C( n_868 ), .Y( n_863 ), .B( n_866 ), .A( n_865 ) );
NAND4X1 (*
integer library_binding = "gsclib090";
 *)
i_26 ( .D( n_876 ),
.C( n_875 ), .Y( n_870 ), .B( n_873 ), .A( n_872 ) );
NAND4X1 (*
integer library_binding = "gsclib090";
 *)
i_4 ( .D( n_1164 ),
.C( n_1696 ), .Y( n_881 ), .B( n_1161 ), .A( n_1548 ) );
NAND4X1 (*
integer library_binding = "gsclib090";
 *)
i_17846 ( .D(
n_1711 ), .C( n_1193 ), .Y( n_920 ), .B( n_1196 ), .A( n_1199 ) );
NAND4X1 (*
integer library_binding = "gsclib090";
 *)
i_17814 ( .D(
n_1708 ), .C( n_1205 ), .Y( n_939 ), .B( n_1208 ), .A( n_1211 ) );
NAND4X1 (*
integer library_binding = "gsclib090";
 *)
i_12794 ( .D(
n_1707 ), .C( n_1706 ), .Y( n_953 ), .B( n_1223 ), .A( n_1226 ) );
NAND4X1 (*
integer library_binding = "gsclib090";
 *)
i_17782 ( .D(
n_1705 ), .C( n_1217 ), .Y( n_958 ), .B( n_1220 ), .A( n_1223 ) );
NAND4X1 (*
integer library_binding = "gsclib090";
 *)
i_17750 ( .D(
n_1702 ), .C( n_1229 ), .Y( n_977 ), .B( n_1232 ), .A( n_1235 ) );
NAND4X1 (*
integer library_binding = "gsclib090";
 *)
i_17718 ( .D(
n_1699 ), .C( n_1244 ), .Y( n_996 ), .B( n_1241 ), .A( n_1247 ) );
NAND4X1 (*
integer library_binding = "gsclib090";
 *)
i_17654 ( .D(
n_1673 ), .C( n_1268 ), .Y( n_1034 ), .B( n_1265 ), .A( n_1271 ) );
NAND4X1 (*
integer library_binding = "gsclib090";
 *)
i_17686 ( .D(
n_1679 ), .C( n_1256 ), .Y( n_1015 ), .B( n_1253 ), .A( n_1259 ) );

NAND2X1 (*
integer library_binding = "gsclib090";
 *)
i_32 ( .Y(
\next_bin[4]  ), .B( n_1176 ), .A( n_1175 ) );
NAND2X1 (*
integer library_binding = "gsclib090";
 *)
i_126 ( .Y(
n_1654 ), .B( n_892 ), .A( n_1655 ) );
NAND2X1 (*
integer library_binding = "gsclib090";
 *)
i_132 ( .Y(
n_1650 ), .B( n_903 ), .A( n_1651 ) );
NAND2X1 (*
integer library_binding = "gsclib090";
 *)
i_135 ( .Y(
n_1648 ), .B( n_909 ), .A( n_1649 ) );
NAND2X1 (*
integer library_binding = "gsclib090";
 *)
i_141 ( .Y(
n_1644 ), .B( n_919 ), .A( n_1645 ) );
NAND2X1 (*
integer library_binding = "gsclib090";
 *)
i_144 ( .Y(
n_1642 ), .B( n_923 ), .A( n_1643 ) );
NAND2X1 (*
integer library_binding = "gsclib090";
 *)
i_147 ( .Y(
n_1640 ), .B( n_928 ), .A( n_1641 ) );
NAND2X1 (*
integer library_binding = "gsclib090";
 *)
i_156 ( .Y(
n_1634 ), .B( n_942 ), .A( n_1635 ) );
NAND2X1 (*
integer library_binding = "gsclib090";
 *)
i_159 ( .Y(
n_1632 ), .B( n_947 ), .A( n_1633 ) );
NAND2X1 (*
integer library_binding = "gsclib090";
 *)
i_165 ( .Y(
n_1628 ), .B( n_957 ), .A( n_1629 ) );
NAND2X1 (*
integer library_binding = "gsclib090";
 *)
i_168 ( .Y(
n_1626 ), .B( n_961 ), .A( n_1627 ) );
NAND2X1 (*
integer library_binding = "gsclib090";
 *)
i_171 ( .Y(
n_1624 ), .B( n_966 ), .A( n_1625 ) );
NAND2X1 (*
integer library_binding = "gsclib090";
 *)
i_180 ( .Y(
n_1618 ), .B( n_980 ), .A( n_1619 ) );
NAND2X1 (*
integer library_binding = "gsclib090";
 *)
i_183 ( .Y(
n_1616 ), .B( n_985 ), .A( n_1617 ) );
NAND2X1 (*
integer library_binding = "gsclib090";
 *)
i_192 ( .Y(
n_1610 ), .B( n_999 ), .A( n_1611 ) );
NAND2X1 (*
integer library_binding = "gsclib090";
 *)
i_195 ( .Y(
n_1608 ), .B( n_1004 ), .A( n_1609 ) );
NAND2X1 (*
integer library_binding = "gsclib090";
 *)
i_204 ( .Y(
n_1602 ), .B( n_1018 ), .A( n_1603 ) );
NAND2X1 (*
integer library_binding = "gsclib090";
 *)
i_207 ( .Y(
n_1600 ), .B( n_1023 ), .A( n_1601 ) );
NAND2X1 (*
integer library_binding = "gsclib090";
 *)
i_216 ( .Y(
n_1594 ), .B( n_1037 ), .A( n_1595 ) );
NAND2X1 (*
integer library_binding = "gsclib090";
 *)
i_219 ( .Y(
n_1592 ), .B( n_1042 ), .A( n_1593 ) );
NAND2X1 (*
integer library_binding = "gsclib090";
 *)
i_228 ( .Y(
n_1586 ), .B( n_1056 ), .A( n_1587 ) );
NAND2X1 (*
integer library_binding = "gsclib090";
 *)
i_231 ( .Y(
n_1584 ), .B( n_1061 ), .A( n_1585 ) );
NAND2X1 (*
integer library_binding = "gsclib090";
 *)
i_240 ( .Y(
n_1578 ), .B( n_1075 ), .A( n_1579 ) );
NAND2X1 (*
integer library_binding = "gsclib090";
 *)
i_243 ( .Y(
n_1576 ), .B( n_1080 ), .A( n_1577 ) );
NAND2X1 (*
integer library_binding = "gsclib090";
 *)
i_252 ( .Y(
n_1570 ), .B( n_1094 ), .A( n_1571 ) );
NAND2X1 (*
integer library_binding = "gsclib090";
 *)
i_255 ( .Y(
n_1568 ), .B( n_1099 ), .A( n_1569 ) );
NAND2X1 (*
integer library_binding = "gsclib090";
 *)
i_264 ( .Y(
n_1562 ), .B( n_1113 ), .A( n_1563 ) );
NAND2X1 (*
integer library_binding = "gsclib090";
 *)
i_267 ( .Y(
n_1560 ), .B( n_1118 ), .A( n_1561 ) );
NAND2X1 (*
integer library_binding = "gsclib090";
 *)
i_276 ( .Y(
n_1554 ), .B( n_1132 ), .A( n_1555 ) );
NAND2X1 (*
integer library_binding = "gsclib090";
 *)
i_309 ( .Y(
n_1541 ), .B( n_694 ), .A( n_1359 ) );
NAND2X1 (*
integer library_binding = "gsclib090";
 *)
i_314 ( .Y(
n_1538 ), .B( n_695 ), .A( n_1536 ) );
NAND2X1 (*
integer library_binding = "gsclib090";
 *)
i_317 ( .Y(
n_1537 ), .B( THERM[58] ), .A( THERM[60] ) );
NAND2X1 (*
integer library_binding = "gsclib090";
 *)
i_318 ( .Y(
n_1536 ), .B( THERM[59] ), .A( THERM[60] ) );
NAND2X1 (*
integer library_binding = "gsclib090";
 *)
i_322 ( .Y(
n_1534 ), .B( THERM[57] ), .A( THERM[59] ) );
NAND2X1 (*
integer library_binding = "gsclib090";
 *)
i_323 ( .Y(
n_1533 ), .B( THERM[58] ), .A( THERM[59] ) );
NAND2X1 (*
integer library_binding = "gsclib090";
 *)
i_327 ( .Y(
n_1531 ), .B( THERM[56] ), .A( THERM[58] ) );
NAND2X1 (*
integer library_binding = "gsclib090";
 *)
i_328 ( .Y(
n_1530 ), .B( THERM[57] ), .A( THERM[58] ) );
NAND2X1 (*
integer library_binding = "gsclib090";
 *)
i_332 ( .Y(
n_1528 ), .B( THERM[55] ), .A( THERM[57] ) );
NAND2X1 (*
integer library_binding = "gsclib090";
 *)
i_333 ( .Y(
n_1527 ), .B( THERM[56] ), .A( THERM[57] ) );
NAND2X1 (*
integer library_binding = "gsclib090";
 *)
i_337 ( .Y(
n_1525 ), .B( THERM[54] ), .A( THERM[56] ) );
NAND2X1 (*
integer library_binding = "gsclib090";
 *)
i_338 ( .Y(
n_1524 ), .B( THERM[55] ), .A( THERM[56] ) );
NAND2X1 (*
integer library_binding = "gsclib090";
 *)
i_342 ( .Y(
n_1522 ), .B( THERM[53] ), .A( THERM[55] ) );
NAND2X1 (*
integer library_binding = "gsclib090";
 *)
i_343 ( .Y(
n_1521 ), .B( THERM[54] ), .A( THERM[55] ) );
NAND2X1 (*
integer library_binding = "gsclib090";
 *)
i_347 ( .Y(
n_1519 ), .B( THERM[52] ), .A( THERM[54] ) );
NAND2X1 (*
integer library_binding = "gsclib090";
 *)
i_348 ( .Y(
n_1518 ), .B( THERM[53] ), .A( THERM[54] ) );
NAND2X1 (*
integer library_binding = "gsclib090";
 *)
i_352 ( .Y(
n_1516 ), .B( THERM[51] ), .A( THERM[53] ) );
NAND2X1 (*
integer library_binding = "gsclib090";
 *)
i_353 ( .Y(
n_1515 ), .B( THERM[52] ), .A( THERM[53] ) );
NAND2X1 (*
integer library_binding = "gsclib090";
 *)
i_357 ( .Y(
n_1513 ), .B( THERM[50] ), .A( THERM[52] ) );
NAND2X1 (*
integer library_binding = "gsclib090";
 *)
i_358 ( .Y(
n_1512 ), .B( THERM[51] ), .A( THERM[52] ) );
NAND2X1 (*
integer library_binding = "gsclib090";
 *)
i_362 ( .Y(
n_1510 ), .B( THERM[49] ), .A( THERM[51] ) );
NAND2X1 (*
integer library_binding = "gsclib090";
 *)
i_363 ( .Y(
n_1509 ), .B( THERM[50] ), .A( THERM[51] ) );
NAND2X1 (*
integer library_binding = "gsclib090";
 *)
i_367 ( .Y(
n_1507 ), .B( THERM[48] ), .A( THERM[50] ) );
NAND2X1 (*
integer library_binding = "gsclib090";
 *)
i_368 ( .Y(
n_1506 ), .B( THERM[49] ), .A( THERM[50] ) );
NAND2X1 (*
integer library_binding = "gsclib090";
 *)
i_372 ( .Y(
n_1504 ), .B( THERM[47] ), .A( THERM[49] ) );
NAND2X1 (*
integer library_binding = "gsclib090";
 *)
i_373 ( .Y(
n_1503 ), .B( THERM[48] ), .A( THERM[49] ) );
NAND2X1 (*
integer library_binding = "gsclib090";
 *)
i_377 ( .Y(
n_1501 ), .B( THERM[46] ), .A( THERM[48] ) );
NAND2X1 (*
integer library_binding = "gsclib090";
 *)
i_378 ( .Y(
n_1500 ), .B( THERM[47] ), .A( THERM[48] ) );
NAND2X1 (*
integer library_binding = "gsclib090";
 *)
i_382 ( .Y(
n_1498 ), .B( THERM[45] ), .A( THERM[47] ) );
NAND2X1 (*
integer library_binding = "gsclib090";
 *)
i_383 ( .Y(
n_1497 ), .B( THERM[46] ), .A( THERM[47] ) );
NAND2X1 (*
integer library_binding = "gsclib090";
 *)
i_387 ( .Y(
n_1495 ), .B( THERM[44] ), .A( THERM[46] ) );
NAND2X1 (*
integer library_binding = "gsclib090";
 *)
i_388 ( .Y(
n_1494 ), .B( THERM[45] ), .A( THERM[46] ) );
NAND2X1 (*
integer library_binding = "gsclib090";
 *)
i_392 ( .Y(
n_1492 ), .B( THERM[43] ), .A( THERM[45] ) );
NAND2X1 (*
integer library_binding = "gsclib090";
 *)
i_393 ( .Y(
n_1491 ), .B( THERM[44] ), .A( THERM[45] ) );
NAND2X1 (*
integer library_binding = "gsclib090";
 *)
i_397 ( .Y(
n_1489 ), .B( THERM[42] ), .A( THERM[44] ) );
NAND2X1 (*
integer library_binding = "gsclib090";
 *)
i_398 ( .Y(
n_1488 ), .B( THERM[43] ), .A( THERM[44] ) );
NAND2X1 (*
integer library_binding = "gsclib090";
 *)
i_402 ( .Y(
n_1486 ), .B( THERM[41] ), .A( THERM[43] ) );
NAND2X1 (*
integer library_binding = "gsclib090";
 *)
i_403 ( .Y(
n_1485 ), .B( THERM[42] ), .A( THERM[43] ) );
NAND2X1 (*
integer library_binding = "gsclib090";
 *)
i_407 ( .Y(
n_1483 ), .B( THERM[40] ), .A( THERM[42] ) );
NAND2X1 (*
integer library_binding = "gsclib090";
 *)
i_408 ( .Y(
n_1482 ), .B( THERM[41] ), .A( THERM[42] ) );
NAND2X1 (*
integer library_binding = "gsclib090";
 *)
i_412 ( .Y(
n_1480 ), .B( THERM[39] ), .A( THERM[41] ) );
NAND2X1 (*
integer library_binding = "gsclib090";
 *)
i_413 ( .Y(
n_1479 ), .B( THERM[40] ), .A( THERM[41] ) );
NAND2X1 (*
integer library_binding = "gsclib090";
 *)
i_417 ( .Y(
n_1477 ), .B( THERM[38] ), .A( THERM[40] ) );
NAND2X1 (*
integer library_binding = "gsclib090";
 *)
i_418 ( .Y(
n_1476 ), .B( THERM[39] ), .A( THERM[40] ) );
NAND2X1 (*
integer library_binding = "gsclib090";
 *)
i_422 ( .Y(
n_1474 ), .B( THERM[37] ), .A( THERM[39] ) );
NAND2X1 (*
integer library_binding = "gsclib090";
 *)
i_423 ( .Y(
n_1473 ), .B( THERM[38] ), .A( THERM[39] ) );
NAND2X1 (*
integer library_binding = "gsclib090";
 *)
i_427 ( .Y(
n_1471 ), .B( THERM[36] ), .A( THERM[38] ) );
NAND2X1 (*
integer library_binding = "gsclib090";
 *)
i_428 ( .Y(
n_1470 ), .B( THERM[37] ), .A( THERM[38] ) );
NAND2X1 (*
integer library_binding = "gsclib090";
 *)
i_432 ( .Y(
n_1468 ), .B( THERM[35] ), .A( THERM[37] ) );
NAND2X1 (*
integer library_binding = "gsclib090";
 *)
i_433 ( .Y(
n_1467 ), .B( THERM[36] ), .A( THERM[37] ) );
NAND2X1 (*
integer library_binding = "gsclib090";
 *)
i_437 ( .Y(
n_1465 ), .B( THERM[34] ), .A( THERM[36] ) );
NAND2X1 (*
integer library_binding = "gsclib090";
 *)
i_438 ( .Y(
n_1464 ), .B( THERM[35] ), .A( THERM[36] ) );
NAND2X1 (*
integer library_binding = "gsclib090";
 *)
i_442 ( .Y(
n_1462 ), .B( THERM[33] ), .A( THERM[35] ) );
NAND2X1 (*
integer library_binding = "gsclib090";
 *)
i_443 ( .Y(
n_1461 ), .B( THERM[34] ), .A( THERM[35] ) );
NAND2X1 (*
integer library_binding = "gsclib090";
 *)
i_447 ( .Y(
n_1459 ), .B( THERM[32] ), .A( THERM[34] ) );
NAND2X1 (*
integer library_binding = "gsclib090";
 *)
i_448 ( .Y(
n_1458 ), .B( THERM[33] ), .A( THERM[34] ) );
NAND2X1 (*
integer library_binding = "gsclib090";
 *)
i_452 ( .Y(
n_1456 ), .B( THERM[31] ), .A( THERM[33] ) );
NAND2X1 (*
integer library_binding = "gsclib090";
 *)
i_453 ( .Y(
n_1455 ), .B( THERM[32] ), .A( THERM[33] ) );
NAND2X1 (*
integer library_binding = "gsclib090";
 *)
i_457 ( .Y(
n_1453 ), .B( THERM[30] ), .A( THERM[32] ) );
NAND2X1 (*
integer library_binding = "gsclib090";
 *)
i_458 ( .Y(
n_1452 ), .B( THERM[31] ), .A( THERM[32] ) );
NAND2X1 (*
integer library_binding = "gsclib090";
 *)
i_462 ( .Y(
n_1450 ), .B( THERM[29] ), .A( THERM[31] ) );
NAND2X1 (*
integer library_binding = "gsclib090";
 *)
i_463 ( .Y(
n_1449 ), .B( THERM[30] ), .A( THERM[31] ) );
NAND2X1 (*
integer library_binding = "gsclib090";
 *)
i_467 ( .Y(
n_1447 ), .B( THERM[28] ), .A( THERM[30] ) );
NAND2X1 (*
integer library_binding = "gsclib090";
 *)
i_468 ( .Y(
n_1446 ), .B( THERM[29] ), .A( THERM[30] ) );
NAND2X1 (*
integer library_binding = "gsclib090";
 *)
i_472 ( .Y(
n_1444 ), .B( THERM[27] ), .A( THERM[29] ) );
NAND2X1 (*
integer library_binding = "gsclib090";
 *)
i_473 ( .Y(
n_1443 ), .B( THERM[28] ), .A( THERM[29] ) );
NAND2X1 (*
integer library_binding = "gsclib090";
 *)
i_477 ( .Y(
n_1441 ), .B( THERM[26] ), .A( THERM[28] ) );
NAND2X1 (*
integer library_binding = "gsclib090";
 *)
i_478 ( .Y(
n_1440 ), .B( THERM[27] ), .A( THERM[28] ) );
NAND2X1 (*
integer library_binding = "gsclib090";
 *)
i_482 ( .Y(
n_1438 ), .B( THERM[25] ), .A( THERM[27] ) );
NAND2X1 (*
integer library_binding = "gsclib090";
 *)
i_483 ( .Y(
n_1437 ), .B( THERM[26] ), .A( THERM[27] ) );
NAND2X1 (*
integer library_binding = "gsclib090";
 *)
i_487 ( .Y(
n_1435 ), .B( THERM[24] ), .A( THERM[26] ) );
NAND2X1 (*
integer library_binding = "gsclib090";
 *)
i_488 ( .Y(
n_1434 ), .B( THERM[25] ), .A( THERM[26] ) );
NAND2X1 (*
integer library_binding = "gsclib090";
 *)
i_492 ( .Y(
n_1432 ), .B( THERM[23] ), .A( THERM[25] ) );
NAND2X1 (*
integer library_binding = "gsclib090";
 *)
i_493 ( .Y(
n_1431 ), .B( THERM[24] ), .A( THERM[25] ) );
NAND2X1 (*
integer library_binding = "gsclib090";
 *)
i_497 ( .Y(
n_1429 ), .B( THERM[22] ), .A( THERM[24] ) );
NAND2X1 (*
integer library_binding = "gsclib090";
 *)
i_498 ( .Y(
n_1428 ), .B( THERM[23] ), .A( THERM[24] ) );
NAND2X1 (*
integer library_binding = "gsclib090";
 *)
i_502 ( .Y(
n_1426 ), .B( THERM[21] ), .A( THERM[23] ) );
NAND2X1 (*
integer library_binding = "gsclib090";
 *)
i_503 ( .Y(
n_1425 ), .B( THERM[22] ), .A( THERM[23] ) );
NAND2X1 (*
integer library_binding = "gsclib090";
 *)
i_507 ( .Y(
n_1423 ), .B( THERM[20] ), .A( THERM[22] ) );
NAND2X1 (*
integer library_binding = "gsclib090";
 *)
i_508 ( .Y(
n_1422 ), .B( THERM[21] ), .A( THERM[22] ) );
NAND2X1 (*
integer library_binding = "gsclib090";
 *)
i_512 ( .Y(
n_1420 ), .B( THERM[19] ), .A( THERM[21] ) );
NAND2X1 (*
integer library_binding = "gsclib090";
 *)
i_513 ( .Y(
n_1419 ), .B( THERM[20] ), .A( THERM[21] ) );
NAND2X1 (*
integer library_binding = "gsclib090";
 *)
i_517 ( .Y(
n_1417 ), .B( THERM[18] ), .A( THERM[20] ) );
NAND2X1 (*
integer library_binding = "gsclib090";
 *)
i_518 ( .Y(
n_1416 ), .B( THERM[19] ), .A( THERM[20] ) );
NAND2X1 (*
integer library_binding = "gsclib090";
 *)
i_522 ( .Y(
n_1414 ), .B( THERM[17] ), .A( THERM[19] ) );
NAND2X1 (*
integer library_binding = "gsclib090";
 *)
i_523 ( .Y(
n_1413 ), .B( THERM[18] ), .A( THERM[19] ) );
NAND2X1 (*
integer library_binding = "gsclib090";
 *)
i_527 ( .Y(
n_1411 ), .B( THERM[16] ), .A( THERM[18] ) );
NAND2X1 (*
integer library_binding = "gsclib090";
 *)
i_528 ( .Y(
n_1410 ), .B( THERM[17] ), .A( THERM[18] ) );
NAND2X1 (*
integer library_binding = "gsclib090";
 *)
i_532 ( .Y(
n_1408 ), .B( THERM[15] ), .A( THERM[17] ) );
NAND2X1 (*
integer library_binding = "gsclib090";
 *)
i_533 ( .Y(
n_1407 ), .B( THERM[16] ), .A( THERM[17] ) );
NAND2X1 (*
integer library_binding = "gsclib090";
 *)
i_537 ( .Y(
n_1405 ), .B( THERM[14] ), .A( THERM[16] ) );
NAND2X1 (*
integer library_binding = "gsclib090";
 *)
i_538 ( .Y(
n_1404 ), .B( THERM[15] ), .A( THERM[16] ) );
NAND2X1 (*
integer library_binding = "gsclib090";
 *)
i_542 ( .Y(
n_1402 ), .B( THERM[13] ), .A( THERM[15] ) );
NAND2X1 (*
integer library_binding = "gsclib090";
 *)
i_543 ( .Y(
n_1401 ), .B( THERM[14] ), .A( THERM[15] ) );
NAND2X1 (*
integer library_binding = "gsclib090";
 *)
i_547 ( .Y(
n_1399 ), .B( THERM[12] ), .A( THERM[14] ) );
NAND2X1 (*
integer library_binding = "gsclib090";
 *)
i_548 ( .Y(
n_1398 ), .B( THERM[13] ), .A( THERM[14] ) );
NAND2X1 (*
integer library_binding = "gsclib090";
 *)
i_552 ( .Y(
n_1396 ), .B( THERM[11] ), .A( THERM[13] ) );
NAND2X1 (*
integer library_binding = "gsclib090";
 *)
i_553 ( .Y(
n_1395 ), .B( THERM[12] ), .A( THERM[13] ) );
NAND2X1 (*
integer library_binding = "gsclib090";
 *)
i_557 ( .Y(
n_1393 ), .B( THERM[10] ), .A( THERM[12] ) );
NAND2X1 (*
integer library_binding = "gsclib090";
 *)
i_558 ( .Y(
n_1392 ), .B( THERM[11] ), .A( THERM[12] ) );
NAND2X1 (*
integer library_binding = "gsclib090";
 *)
i_562 ( .Y(
n_1390 ), .B( THERM[9] ), .A( THERM[11] ) );
NAND2X1 (*
integer library_binding = "gsclib090";
 *)
i_563 ( .Y(
n_1389 ), .B( THERM[10] ), .A( THERM[11] ) );
NAND2X1 (*
integer library_binding = "gsclib090";
 *)
i_567 ( .Y(
n_1387 ), .B( THERM[8] ), .A( THERM[10] ) );
NAND2X1 (*
integer library_binding = "gsclib090";
 *)
i_568 ( .Y(
n_1386 ), .B( THERM[9] ), .A( THERM[10] ) );
NAND2X1 (*
integer library_binding = "gsclib090";
 *)
i_572 ( .Y(
n_1384 ), .B( THERM[7] ), .A( THERM[9] ) );
NAND2X1 (*
integer library_binding = "gsclib090";
 *)
i_573 ( .Y(
n_1383 ), .B( THERM[8] ), .A( THERM[9] ) );
NAND2X1 (*
integer library_binding = "gsclib090";
 *)
i_577 ( .Y(
n_1381 ), .B( THERM[6] ), .A( THERM[8] ) );
NAND2X1 (*
integer library_binding = "gsclib090";
 *)
i_578 ( .Y(
n_1380 ), .B( THERM[7] ), .A( THERM[8] ) );
NAND2X1 (*
integer library_binding = "gsclib090";
 *)
i_582 ( .Y(
n_1378 ), .B( THERM[5] ), .A( THERM[7] ) );
NAND2X1 (*
integer library_binding = "gsclib090";
 *)
i_583 ( .Y(
n_1377 ), .B( THERM[6] ), .A( THERM[7] ) );
NAND2X1 (*
integer library_binding = "gsclib090";
 *)
i_587 ( .Y(
n_1375 ), .B( THERM[4] ), .A( THERM[6] ) );
NAND2X1 (*
integer library_binding = "gsclib090";
 *)
i_588 ( .Y(
n_1374 ), .B( THERM[5] ), .A( THERM[6] ) );
NAND2X1 (*
integer library_binding = "gsclib090";
 *)
i_592 ( .Y(
n_1372 ), .B( THERM[3] ), .A( THERM[5] ) );
NAND2X1 (*
integer library_binding = "gsclib090";
 *)
i_593 ( .Y(
n_1371 ), .B( THERM[4] ), .A( THERM[5] ) );
NAND2X1 (*
integer library_binding = "gsclib090";
 *)
i_597 ( .Y(
n_1369 ), .B( THERM[2] ), .A( THERM[4] ) );
NAND2X1 (*
integer library_binding = "gsclib090";
 *)
i_598 ( .Y(
n_1368 ), .B( THERM[3] ), .A( THERM[4] ) );
NAND2X1 (*
integer library_binding = "gsclib090";
 *)
i_602 ( .Y(
n_1366 ), .B( THERM[1] ), .A( THERM[3] ) );
NAND2X1 (*
integer library_binding = "gsclib090";
 *)
i_603 ( .Y(
n_1365 ), .B( THERM[2] ), .A( THERM[3] ) );
NAND2X1 (*
integer library_binding = "gsclib090";
 *)
i_608 ( .Y(
n_1361 ), .B( THERM[1] ), .A( THERM[2] ) );
NAND2X1 (*
integer library_binding = "gsclib090";
 *)
i_609 ( .Y(
n_1360 ), .B( n_800 ), .A( n_1361 ) );
NAND2X1 (*
integer library_binding = "gsclib090";
 *)
i_5 ( .Y( n_1359 ),
.B( THERM[62] ), .A( THERM[61] ) );
NAND2X1 (*
integer library_binding = "gsclib090";
 *)
i_745 ( .Y(
n_1355 ), .B( n_696 ), .A( n_1353 ) );
NAND2X1 (*
integer library_binding = "gsclib090";
 *)
i_748 ( .Y(
n_1354 ), .B( n_1532 ), .A( n_1538 ) );
NAND2X1 (*
integer library_binding = "gsclib090";
 *)
i_749 ( .Y(
n_1353 ), .B( n_1535 ), .A( n_1538 ) );
NAND2X1 (*
integer library_binding = "gsclib090";
 *)
i_753 ( .Y(
n_1351 ), .B( n_1529 ), .A( n_1535 ) );
NAND2X1 (*
integer library_binding = "gsclib090";
 *)
i_754 ( .Y(
n_1350 ), .B( n_1532 ), .A( n_1535 ) );
NAND2X1 (*
integer library_binding = "gsclib090";
 *)
i_758 ( .Y(
n_1348 ), .B( n_1526 ), .A( n_1532 ) );
NAND2X1 (*
integer library_binding = "gsclib090";
 *)
i_759 ( .Y(
n_1347 ), .B( n_1529 ), .A( n_1532 ) );
NAND2X1 (*
integer library_binding = "gsclib090";
 *)
i_763 ( .Y(
n_1345 ), .B( n_1523 ), .A( n_1529 ) );
NAND2X1 (*
integer library_binding = "gsclib090";
 *)
i_764 ( .Y(
n_1344 ), .B( n_1526 ), .A( n_1529 ) );
NAND2X1 (*
integer library_binding = "gsclib090";
 *)
i_768 ( .Y(
n_1342 ), .B( n_1520 ), .A( n_1526 ) );
NAND2X1 (*
integer library_binding = "gsclib090";
 *)
i_769 ( .Y(
n_1341 ), .B( n_1523 ), .A( n_1526 ) );
NAND2X1 (*
integer library_binding = "gsclib090";
 *)
i_773 ( .Y(
n_1339 ), .B( n_1517 ), .A( n_1523 ) );
NAND2X1 (*
integer library_binding = "gsclib090";
 *)
i_774 ( .Y(
n_1338 ), .B( n_1520 ), .A( n_1523 ) );
NAND2X1 (*
integer library_binding = "gsclib090";
 *)
i_778 ( .Y(
n_1336 ), .B( n_1514 ), .A( n_1520 ) );
NAND2X1 (*
integer library_binding = "gsclib090";
 *)
i_779 ( .Y(
n_1335 ), .B( n_1517 ), .A( n_1520 ) );
NAND2X1 (*
integer library_binding = "gsclib090";
 *)
i_783 ( .Y(
n_1333 ), .B( n_1511 ), .A( n_1517 ) );
NAND2X1 (*
integer library_binding = "gsclib090";
 *)
i_784 ( .Y(
n_1332 ), .B( n_1514 ), .A( n_1517 ) );
NAND2X1 (*
integer library_binding = "gsclib090";
 *)
i_788 ( .Y(
n_1330 ), .B( n_1508 ), .A( n_1514 ) );
NAND2X1 (*
integer library_binding = "gsclib090";
 *)
i_789 ( .Y(
n_1329 ), .B( n_1511 ), .A( n_1514 ) );
NAND2X1 (*
integer library_binding = "gsclib090";
 *)
i_793 ( .Y(
n_1327 ), .B( n_1505 ), .A( n_1511 ) );
NAND2X1 (*
integer library_binding = "gsclib090";
 *)
i_794 ( .Y(
n_1326 ), .B( n_1508 ), .A( n_1511 ) );
NAND2X1 (*
integer library_binding = "gsclib090";
 *)
i_798 ( .Y(
n_1324 ), .B( n_1502 ), .A( n_1508 ) );
NAND2X1 (*
integer library_binding = "gsclib090";
 *)
i_799 ( .Y(
n_1323 ), .B( n_1505 ), .A( n_1508 ) );
NAND2X1 (*
integer library_binding = "gsclib090";
 *)
i_803 ( .Y(
n_1321 ), .B( n_1499 ), .A( n_1505 ) );
NAND2X1 (*
integer library_binding = "gsclib090";
 *)
i_804 ( .Y(
n_1320 ), .B( n_1502 ), .A( n_1505 ) );
NAND2X1 (*
integer library_binding = "gsclib090";
 *)
i_808 ( .Y(
n_1318 ), .B( n_1496 ), .A( n_1502 ) );
NAND2X1 (*
integer library_binding = "gsclib090";
 *)
i_809 ( .Y(
n_1317 ), .B( n_1499 ), .A( n_1502 ) );
NAND2X1 (*
integer library_binding = "gsclib090";
 *)
i_813 ( .Y(
n_1315 ), .B( n_1493 ), .A( n_1499 ) );
NAND2X1 (*
integer library_binding = "gsclib090";
 *)
i_814 ( .Y(
n_1314 ), .B( n_1496 ), .A( n_1499 ) );
NAND2X1 (*
integer library_binding = "gsclib090";
 *)
i_818 ( .Y(
n_1312 ), .B( n_1490 ), .A( n_1496 ) );
NAND2X1 (*
integer library_binding = "gsclib090";
 *)
i_819 ( .Y(
n_1311 ), .B( n_1493 ), .A( n_1496 ) );
NAND2X1 (*
integer library_binding = "gsclib090";
 *)
i_823 ( .Y(
n_1309 ), .B( n_1487 ), .A( n_1493 ) );
NAND2X1 (*
integer library_binding = "gsclib090";
 *)
i_824 ( .Y(
n_1308 ), .B( n_1490 ), .A( n_1493 ) );
NAND2X1 (*
integer library_binding = "gsclib090";
 *)
i_828 ( .Y(
n_1306 ), .B( n_1484 ), .A( n_1490 ) );
NAND2X1 (*
integer library_binding = "gsclib090";
 *)
i_829 ( .Y(
n_1305 ), .B( n_1487 ), .A( n_1490 ) );
NAND2X1 (*
integer library_binding = "gsclib090";
 *)
i_833 ( .Y(
n_1303 ), .B( n_1481 ), .A( n_1487 ) );
NAND2X1 (*
integer library_binding = "gsclib090";
 *)
i_834 ( .Y(
n_1302 ), .B( n_1484 ), .A( n_1487 ) );
NAND2X1 (*
integer library_binding = "gsclib090";
 *)
i_838 ( .Y(
n_1300 ), .B( n_1478 ), .A( n_1484 ) );
NAND2X1 (*
integer library_binding = "gsclib090";
 *)
i_839 ( .Y(
n_1299 ), .B( n_1481 ), .A( n_1484 ) );
NAND2X1 (*
integer library_binding = "gsclib090";
 *)
i_843 ( .Y(
n_1297 ), .B( n_1475 ), .A( n_1481 ) );
NAND2X1 (*
integer library_binding = "gsclib090";
 *)
i_844 ( .Y(
n_1296 ), .B( n_1478 ), .A( n_1481 ) );
NAND2X1 (*
integer library_binding = "gsclib090";
 *)
i_848 ( .Y(
n_1294 ), .B( n_1472 ), .A( n_1478 ) );
NAND2X1 (*
integer library_binding = "gsclib090";
 *)
i_849 ( .Y(
n_1293 ), .B( n_1475 ), .A( n_1478 ) );
NAND2X1 (*
integer library_binding = "gsclib090";
 *)
i_853 ( .Y(
n_1291 ), .B( n_1469 ), .A( n_1475 ) );
NAND2X1 (*
integer library_binding = "gsclib090";
 *)
i_854 ( .Y(
n_1290 ), .B( n_1472 ), .A( n_1475 ) );
NAND2X1 (*
integer library_binding = "gsclib090";
 *)
i_858 ( .Y(
n_1288 ), .B( n_1466 ), .A( n_1472 ) );
NAND2X1 (*
integer library_binding = "gsclib090";
 *)
i_859 ( .Y(
n_1287 ), .B( n_1469 ), .A( n_1472 ) );
NAND2X1 (*
integer library_binding = "gsclib090";
 *)
i_863 ( .Y(
n_1285 ), .B( n_1463 ), .A( n_1469 ) );
NAND2X1 (*
integer library_binding = "gsclib090";
 *)
i_864 ( .Y(
n_1284 ), .B( n_1466 ), .A( n_1469 ) );
NAND2X1 (*
integer library_binding = "gsclib090";
 *)
i_868 ( .Y(
n_1282 ), .B( n_1460 ), .A( n_1466 ) );
NAND2X1 (*
integer library_binding = "gsclib090";
 *)
i_869 ( .Y(
n_1281 ), .B( n_1463 ), .A( n_1466 ) );
NAND2X1 (*
integer library_binding = "gsclib090";
 *)
i_873 ( .Y(
n_1279 ), .B( n_1457 ), .A( n_1463 ) );
NAND2X1 (*
integer library_binding = "gsclib090";
 *)
i_874 ( .Y(
n_1278 ), .B( n_1460 ), .A( n_1463 ) );
NAND2X1 (*
integer library_binding = "gsclib090";
 *)
i_878 ( .Y(
n_1276 ), .B( n_1454 ), .A( n_1460 ) );
NAND2X1 (*
integer library_binding = "gsclib090";
 *)
i_879 ( .Y(
n_1275 ), .B( n_1457 ), .A( n_1460 ) );
NAND2X1 (*
integer library_binding = "gsclib090";
 *)
i_883 ( .Y(
n_1273 ), .B( n_1451 ), .A( n_1457 ) );
NAND2X1 (*
integer library_binding = "gsclib090";
 *)
i_884 ( .Y(
n_1272 ), .B( n_1454 ), .A( n_1457 ) );
NAND2X1 (*
integer library_binding = "gsclib090";
 *)
i_888 ( .Y(
n_1270 ), .B( n_1448 ), .A( n_1454 ) );
NAND2X1 (*
integer library_binding = "gsclib090";
 *)
i_889 ( .Y(
n_1269 ), .B( n_1451 ), .A( n_1454 ) );
NAND2X1 (*
integer library_binding = "gsclib090";
 *)
i_893 ( .Y(
n_1267 ), .B( n_1445 ), .A( n_1451 ) );
NAND2X1 (*
integer library_binding = "gsclib090";
 *)
i_894 ( .Y(
n_1266 ), .B( n_1448 ), .A( n_1451 ) );
NAND2X1 (*
integer library_binding = "gsclib090";
 *)
i_898 ( .Y(
n_1264 ), .B( n_1442 ), .A( n_1448 ) );
NAND2X1 (*
integer library_binding = "gsclib090";
 *)
i_899 ( .Y(
n_1263 ), .B( n_1445 ), .A( n_1448 ) );
NAND2X1 (*
integer library_binding = "gsclib090";
 *)
i_903 ( .Y(
n_1261 ), .B( n_1439 ), .A( n_1445 ) );
NAND2X1 (*
integer library_binding = "gsclib090";
 *)
i_904 ( .Y(
n_1260 ), .B( n_1442 ), .A( n_1445 ) );
NAND2X1 (*
integer library_binding = "gsclib090";
 *)
i_908 ( .Y(
n_1258 ), .B( n_1436 ), .A( n_1442 ) );
NAND2X1 (*
integer library_binding = "gsclib090";
 *)
i_909 ( .Y(
n_1257 ), .B( n_1439 ), .A( n_1442 ) );
NAND2X1 (*
integer library_binding = "gsclib090";
 *)
i_913 ( .Y(
n_1255 ), .B( n_1433 ), .A( n_1439 ) );
NAND2X1 (*
integer library_binding = "gsclib090";
 *)
i_914 ( .Y(
n_1254 ), .B( n_1436 ), .A( n_1439 ) );
NAND2X1 (*
integer library_binding = "gsclib090";
 *)
i_918 ( .Y(
n_1252 ), .B( n_1430 ), .A( n_1436 ) );
NAND2X1 (*
integer library_binding = "gsclib090";
 *)
i_919 ( .Y(
n_1251 ), .B( n_1433 ), .A( n_1436 ) );
NAND2X1 (*
integer library_binding = "gsclib090";
 *)
i_923 ( .Y(
n_1249 ), .B( n_1427 ), .A( n_1433 ) );
NAND2X1 (*
integer library_binding = "gsclib090";
 *)
i_924 ( .Y(
n_1248 ), .B( n_1430 ), .A( n_1433 ) );
NAND2X1 (*
integer library_binding = "gsclib090";
 *)
i_928 ( .Y(
n_1246 ), .B( n_1424 ), .A( n_1430 ) );
NAND2X1 (*
integer library_binding = "gsclib090";
 *)
i_929 ( .Y(
n_1245 ), .B( n_1427 ), .A( n_1430 ) );
NAND2X1 (*
integer library_binding = "gsclib090";
 *)
i_933 ( .Y(
n_1243 ), .B( n_1421 ), .A( n_1427 ) );
NAND2X1 (*
integer library_binding = "gsclib090";
 *)
i_934 ( .Y(
n_1242 ), .B( n_1424 ), .A( n_1427 ) );
NAND2X1 (*
integer library_binding = "gsclib090";
 *)
i_938 ( .Y(
n_1240 ), .B( n_1418 ), .A( n_1424 ) );
NAND2X1 (*
integer library_binding = "gsclib090";
 *)
i_939 ( .Y(
n_1239 ), .B( n_1421 ), .A( n_1424 ) );
NAND2X1 (*
integer library_binding = "gsclib090";
 *)
i_943 ( .Y(
n_1237 ), .B( n_1415 ), .A( n_1421 ) );
NAND2X1 (*
integer library_binding = "gsclib090";
 *)
i_944 ( .Y(
n_1236 ), .B( n_1418 ), .A( n_1421 ) );
NAND2X1 (*
integer library_binding = "gsclib090";
 *)
i_948 ( .Y(
n_1234 ), .B( n_1412 ), .A( n_1418 ) );
NAND2X1 (*
integer library_binding = "gsclib090";
 *)
i_949 ( .Y(
n_1233 ), .B( n_1415 ), .A( n_1418 ) );
NAND2X1 (*
integer library_binding = "gsclib090";
 *)
i_953 ( .Y(
n_1231 ), .B( n_1409 ), .A( n_1415 ) );
NAND2X1 (*
integer library_binding = "gsclib090";
 *)
i_954 ( .Y(
n_1230 ), .B( n_1412 ), .A( n_1415 ) );
NAND2X1 (*
integer library_binding = "gsclib090";
 *)
i_958 ( .Y(
n_1228 ), .B( n_1406 ), .A( n_1412 ) );
NAND2X1 (*
integer library_binding = "gsclib090";
 *)
i_959 ( .Y(
n_1227 ), .B( n_1409 ), .A( n_1412 ) );
NAND2X1 (*
integer library_binding = "gsclib090";
 *)
i_963 ( .Y(
n_1225 ), .B( n_1403 ), .A( n_1409 ) );
NAND2X1 (*
integer library_binding = "gsclib090";
 *)
i_964 ( .Y(
n_1224 ), .B( n_1406 ), .A( n_1409 ) );
NAND2X1 (*
integer library_binding = "gsclib090";
 *)
i_968 ( .Y(
n_1222 ), .B( n_1400 ), .A( n_1406 ) );
NAND2X1 (*
integer library_binding = "gsclib090";
 *)
i_969 ( .Y(
n_1221 ), .B( n_1403 ), .A( n_1406 ) );
NAND2X1 (*
integer library_binding = "gsclib090";
 *)
i_973 ( .Y(
n_1219 ), .B( n_1397 ), .A( n_1403 ) );
NAND2X1 (*
integer library_binding = "gsclib090";
 *)
i_974 ( .Y(
n_1218 ), .B( n_1400 ), .A( n_1403 ) );
NAND2X1 (*
integer library_binding = "gsclib090";
 *)
i_978 ( .Y(
n_1216 ), .B( n_1394 ), .A( n_1400 ) );
NAND2X1 (*
integer library_binding = "gsclib090";
 *)
i_979 ( .Y(
n_1215 ), .B( n_1397 ), .A( n_1400 ) );
NAND2X1 (*
integer library_binding = "gsclib090";
 *)
i_983 ( .Y(
n_1213 ), .B( n_1391 ), .A( n_1397 ) );
NAND2X1 (*
integer library_binding = "gsclib090";
 *)
i_984 ( .Y(
n_1212 ), .B( n_1394 ), .A( n_1397 ) );
NAND2X1 (*
integer library_binding = "gsclib090";
 *)
i_988 ( .Y(
n_1210 ), .B( n_1388 ), .A( n_1394 ) );
NAND2X1 (*
integer library_binding = "gsclib090";
 *)
i_989 ( .Y(
n_1209 ), .B( n_1391 ), .A( n_1394 ) );
NAND2X1 (*
integer library_binding = "gsclib090";
 *)
i_993 ( .Y(
n_1207 ), .B( n_1385 ), .A( n_1391 ) );
NAND2X1 (*
integer library_binding = "gsclib090";
 *)
i_994 ( .Y(
n_1206 ), .B( n_1388 ), .A( n_1391 ) );
NAND2X1 (*
integer library_binding = "gsclib090";
 *)
i_998 ( .Y(
n_1204 ), .B( n_1382 ), .A( n_1388 ) );
NAND2X1 (*
integer library_binding = "gsclib090";
 *)
i_999 ( .Y(
n_1203 ), .B( n_1385 ), .A( n_1388 ) );
NAND2X1 (*
integer library_binding = "gsclib090";
 *)
i_1003 ( .Y(
n_1201 ), .B( n_1379 ), .A( n_1385 ) );
NAND2X1 (*
integer library_binding = "gsclib090";
 *)
i_1004 ( .Y(
n_1200 ), .B( n_1382 ), .A( n_1385 ) );
NAND2X1 (*
integer library_binding = "gsclib090";
 *)
i_1008 ( .Y(
n_1198 ), .B( n_1376 ), .A( n_1382 ) );
NAND2X1 (*
integer library_binding = "gsclib090";
 *)
i_1009 ( .Y(
n_1197 ), .B( n_1379 ), .A( n_1382 ) );
NAND2X1 (*
integer library_binding = "gsclib090";
 *)
i_1013 ( .Y(
n_1195 ), .B( n_1373 ), .A( n_1379 ) );
NAND2X1 (*
integer library_binding = "gsclib090";
 *)
i_1014 ( .Y(
n_1194 ), .B( n_1376 ), .A( n_1379 ) );
NAND2X1 (*
integer library_binding = "gsclib090";
 *)
i_1018 ( .Y(
n_1192 ), .B( n_1370 ), .A( n_1376 ) );
NAND2X1 (*
integer library_binding = "gsclib090";
 *)
i_1019 ( .Y(
n_1191 ), .B( n_1373 ), .A( n_1376 ) );
NAND2X1 (*
integer library_binding = "gsclib090";
 *)
i_1023 ( .Y(
n_1189 ), .B( n_1367 ), .A( n_1373 ) );
NAND2X1 (*
integer library_binding = "gsclib090";
 *)
i_1024 ( .Y(
n_1188 ), .B( n_1370 ), .A( n_1373 ) );
NAND2X1 (*
integer library_binding = "gsclib090";
 *)
i_1028 ( .Y(
n_1186 ), .B( n_1364 ), .A( n_1370 ) );
NAND2X1 (*
integer library_binding = "gsclib090";
 *)
i_1029 ( .Y(
n_1185 ), .B( n_1367 ), .A( n_1370 ) );
NAND2X1 (*
integer library_binding = "gsclib090";
 *)
i_1034 ( .Y(
n_1181 ), .B( n_1364 ), .A( n_1367 ) );
NAND2X1 (*
integer library_binding = "gsclib090";
 *)
i_1035 ( .Y(
n_1180 ), .B( n_801 ), .A( n_1181 ) );
NAND2X1 (*
integer library_binding = "gsclib090";
 *)
i_14452 ( .Y(
n_1152 ), .B( n_1691 ), .A( n_1346 ) );
NAND2X1 (*
integer library_binding = "gsclib090";
 *)
i_10457 ( .Y(
n_1149 ), .B( n_1349 ), .A( n_1352 ) );
NAND2X1 (*
integer library_binding = "gsclib090";
 *)
i_10473 ( .Y(
n_1141 ), .B( n_1346 ), .A( n_1343 ) );
NAND2X1 (*
integer library_binding = "gsclib090";
 *)
i_10481 ( .Y(
n_1136 ), .B( n_1340 ), .A( n_1343 ) );
NAND2X1 (*
integer library_binding = "gsclib090";
 *)
i_10505 ( .Y(
n_1122 ), .B( n_1334 ), .A( n_1331 ) );
NAND2X1 (*
integer library_binding = "gsclib090";
 *)
i_10537 ( .Y(
n_1103 ), .B( n_1322 ), .A( n_1319 ) );
NAND2X1 (*
integer library_binding = "gsclib090";
 *)
i_10569 ( .Y(
n_1084 ), .B( n_1310 ), .A( n_1307 ) );
NAND2X1 (*
integer library_binding = "gsclib090";
 *)
i_10601 ( .Y(
n_1065 ), .B( n_1298 ), .A( n_1295 ) );
NAND2X1 (*
integer library_binding = "gsclib090";
 *)
i_10633 ( .Y(
n_1046 ), .B( n_1286 ), .A( n_1283 ) );
NAND2X1 (*
integer library_binding = "gsclib090";
 *)
i_80 ( .Y( n_820 ),
.B( n_665 ), .A( n_1684 ) );
NAND2X1 (*
integer library_binding = "gsclib090";
 *)
i_14901 ( .Y(
n_885 ), .B( n_886 ), .A( n_1717 ) );
NAND2X1 (*
integer library_binding = "gsclib090";
 *)
i_10881 ( .Y(
n_896 ), .B( n_1193 ), .A( n_1190 ) );
NAND2X1 (*
integer library_binding = "gsclib090";
 *)
i_14876 ( .Y(
n_900 ), .B( n_1715 ), .A( n_1187 ) );
NAND2X1 (*
integer library_binding = "gsclib090";
 *)
i_13875 ( .Y(
n_901 ), .B( n_1180 ), .A( n_1184 ) );
NAND2X1 (*
integer library_binding = "gsclib090";
 *)
i_10825 ( .Y(
n_932 ), .B( n_1214 ), .A( n_1211 ) );
NAND2X1 (*
integer library_binding = "gsclib090";
 *)
i_10761 ( .Y(
n_970 ), .B( n_1238 ), .A( n_1235 ) );
NAND2X1 (*
integer library_binding = "gsclib090";
 *)
i_10729 ( .Y(
n_989 ), .B( n_1250 ), .A( n_1247 ) );
NAND2X1 (*
integer library_binding = "gsclib090";
 *)
i_10697 ( .Y(
n_1008 ), .B( n_1262 ), .A( n_1259 ) );
NAND2X1 (*
integer library_binding = "gsclib090";
 *)
i_10665 ( .Y(
n_1027 ), .B( n_1274 ), .A( n_1271 ) );

NAND3X1 (*
integer library_binding = "gsclib090";
 *)
i_38 ( .C( n_816 ),
.Y( \next_bin[2]  ), .B( n_1172 ), .A( n_822 ) );
NAND3X1 (*
integer library_binding = "gsclib090";
 *)
i_319 ( .C(
n_1533 ), .Y( n_1535 ), .B( n_1536 ), .A( n_1537 ) );
NAND3X1 (*
integer library_binding = "gsclib090";
 *)
i_324 ( .C(
n_1530 ), .Y( n_1532 ), .B( n_1533 ), .A( n_1534 ) );
NAND3X1 (*
integer library_binding = "gsclib090";
 *)
i_329 ( .C(
n_1527 ), .Y( n_1529 ), .B( n_1530 ), .A( n_1531 ) );
NAND3X1 (*
integer library_binding = "gsclib090";
 *)
i_334 ( .C(
n_1524 ), .Y( n_1526 ), .B( n_1527 ), .A( n_1528 ) );
NAND3X1 (*
integer library_binding = "gsclib090";
 *)
i_339 ( .C(
n_1521 ), .Y( n_1523 ), .B( n_1524 ), .A( n_1525 ) );
NAND3X1 (*
integer library_binding = "gsclib090";
 *)
i_344 ( .C(
n_1518 ), .Y( n_1520 ), .B( n_1521 ), .A( n_1522 ) );
NAND3X1 (*
integer library_binding = "gsclib090";
 *)
i_349 ( .C(
n_1515 ), .Y( n_1517 ), .B( n_1518 ), .A( n_1519 ) );
NAND3X1 (*
integer library_binding = "gsclib090";
 *)
i_354 ( .C(
n_1512 ), .Y( n_1514 ), .B( n_1515 ), .A( n_1516 ) );
NAND3X1 (*
integer library_binding = "gsclib090";
 *)
i_359 ( .C(
n_1509 ), .Y( n_1511 ), .B( n_1512 ), .A( n_1513 ) );
NAND3X1 (*
integer library_binding = "gsclib090";
 *)
i_364 ( .C(
n_1506 ), .Y( n_1508 ), .B( n_1509 ), .A( n_1510 ) );
NAND3X1 (*
integer library_binding = "gsclib090";
 *)
i_369 ( .C(
n_1503 ), .Y( n_1505 ), .B( n_1506 ), .A( n_1507 ) );
NAND3X1 (*
integer library_binding = "gsclib090";
 *)
i_374 ( .C(
n_1500 ), .Y( n_1502 ), .B( n_1503 ), .A( n_1504 ) );
NAND3X1 (*
integer library_binding = "gsclib090";
 *)
i_379 ( .C(
n_1497 ), .Y( n_1499 ), .B( n_1500 ), .A( n_1501 ) );
NAND3X1 (*
integer library_binding = "gsclib090";
 *)
i_384 ( .C(
n_1494 ), .Y( n_1496 ), .B( n_1497 ), .A( n_1498 ) );
NAND3X1 (*
integer library_binding = "gsclib090";
 *)
i_389 ( .C(
n_1491 ), .Y( n_1493 ), .B( n_1494 ), .A( n_1495 ) );
NAND3X1 (*
integer library_binding = "gsclib090";
 *)
i_394 ( .C(
n_1488 ), .Y( n_1490 ), .B( n_1491 ), .A( n_1492 ) );
NAND3X1 (*
integer library_binding = "gsclib090";
 *)
i_399 ( .C(
n_1485 ), .Y( n_1487 ), .B( n_1488 ), .A( n_1489 ) );
NAND3X1 (*
integer library_binding = "gsclib090";
 *)
i_404 ( .C(
n_1482 ), .Y( n_1484 ), .B( n_1485 ), .A( n_1486 ) );
NAND3X1 (*
integer library_binding = "gsclib090";
 *)
i_409 ( .C(
n_1479 ), .Y( n_1481 ), .B( n_1482 ), .A( n_1483 ) );
NAND3X1 (*
integer library_binding = "gsclib090";
 *)
i_414 ( .C(
n_1476 ), .Y( n_1478 ), .B( n_1479 ), .A( n_1480 ) );
NAND3X1 (*
integer library_binding = "gsclib090";
 *)
i_419 ( .C(
n_1473 ), .Y( n_1475 ), .B( n_1476 ), .A( n_1477 ) );
NAND3X1 (*
integer library_binding = "gsclib090";
 *)
i_424 ( .C(
n_1470 ), .Y( n_1472 ), .B( n_1473 ), .A( n_1474 ) );
NAND3X1 (*
integer library_binding = "gsclib090";
 *)
i_429 ( .C(
n_1467 ), .Y( n_1469 ), .B( n_1470 ), .A( n_1471 ) );
NAND3X1 (*
integer library_binding = "gsclib090";
 *)
i_434 ( .C(
n_1464 ), .Y( n_1466 ), .B( n_1467 ), .A( n_1468 ) );
NAND3X1 (*
integer library_binding = "gsclib090";
 *)
i_439 ( .C(
n_1461 ), .Y( n_1463 ), .B( n_1464 ), .A( n_1465 ) );
NAND3X1 (*
integer library_binding = "gsclib090";
 *)
i_444 ( .C(
n_1458 ), .Y( n_1460 ), .B( n_1461 ), .A( n_1462 ) );
NAND3X1 (*
integer library_binding = "gsclib090";
 *)
i_449 ( .C(
n_1455 ), .Y( n_1457 ), .B( n_1458 ), .A( n_1459 ) );
NAND3X1 (*
integer library_binding = "gsclib090";
 *)
i_454 ( .C(
n_1452 ), .Y( n_1454 ), .B( n_1455 ), .A( n_1456 ) );
NAND3X1 (*
integer library_binding = "gsclib090";
 *)
i_459 ( .C(
n_1449 ), .Y( n_1451 ), .B( n_1452 ), .A( n_1453 ) );
NAND3X1 (*
integer library_binding = "gsclib090";
 *)
i_464 ( .C(
n_1446 ), .Y( n_1448 ), .B( n_1449 ), .A( n_1450 ) );
NAND3X1 (*
integer library_binding = "gsclib090";
 *)
i_469 ( .C(
n_1443 ), .Y( n_1445 ), .B( n_1446 ), .A( n_1447 ) );
NAND3X1 (*
integer library_binding = "gsclib090";
 *)
i_474 ( .C(
n_1440 ), .Y( n_1442 ), .B( n_1443 ), .A( n_1444 ) );
NAND3X1 (*
integer library_binding = "gsclib090";
 *)
i_479 ( .C(
n_1437 ), .Y( n_1439 ), .B( n_1440 ), .A( n_1441 ) );
NAND3X1 (*
integer library_binding = "gsclib090";
 *)
i_484 ( .C(
n_1434 ), .Y( n_1436 ), .B( n_1437 ), .A( n_1438 ) );
NAND3X1 (*
integer library_binding = "gsclib090";
 *)
i_489 ( .C(
n_1431 ), .Y( n_1433 ), .B( n_1434 ), .A( n_1435 ) );
NAND3X1 (*
integer library_binding = "gsclib090";
 *)
i_494 ( .C(
n_1428 ), .Y( n_1430 ), .B( n_1431 ), .A( n_1432 ) );
NAND3X1 (*
integer library_binding = "gsclib090";
 *)
i_499 ( .C(
n_1425 ), .Y( n_1427 ), .B( n_1428 ), .A( n_1429 ) );
NAND3X1 (*
integer library_binding = "gsclib090";
 *)
i_504 ( .C(
n_1422 ), .Y( n_1424 ), .B( n_1425 ), .A( n_1426 ) );
NAND3X1 (*
integer library_binding = "gsclib090";
 *)
i_509 ( .C(
n_1419 ), .Y( n_1421 ), .B( n_1422 ), .A( n_1423 ) );
NAND3X1 (*
integer library_binding = "gsclib090";
 *)
i_514 ( .C(
n_1416 ), .Y( n_1418 ), .B( n_1419 ), .A( n_1420 ) );
NAND3X1 (*
integer library_binding = "gsclib090";
 *)
i_519 ( .C(
n_1413 ), .Y( n_1415 ), .B( n_1416 ), .A( n_1417 ) );
NAND3X1 (*
integer library_binding = "gsclib090";
 *)
i_524 ( .C(
n_1410 ), .Y( n_1412 ), .B( n_1413 ), .A( n_1414 ) );
NAND3X1 (*
integer library_binding = "gsclib090";
 *)
i_529 ( .C(
n_1407 ), .Y( n_1409 ), .B( n_1410 ), .A( n_1411 ) );
NAND3X1 (*
integer library_binding = "gsclib090";
 *)
i_534 ( .C(
n_1404 ), .Y( n_1406 ), .B( n_1407 ), .A( n_1408 ) );
NAND3X1 (*
integer library_binding = "gsclib090";
 *)
i_539 ( .C(
n_1401 ), .Y( n_1403 ), .B( n_1404 ), .A( n_1405 ) );
NAND3X1 (*
integer library_binding = "gsclib090";
 *)
i_544 ( .C(
n_1398 ), .Y( n_1400 ), .B( n_1401 ), .A( n_1402 ) );
NAND3X1 (*
integer library_binding = "gsclib090";
 *)
i_549 ( .C(
n_1395 ), .Y( n_1397 ), .B( n_1398 ), .A( n_1399 ) );
NAND3X1 (*
integer library_binding = "gsclib090";
 *)
i_554 ( .C(
n_1392 ), .Y( n_1394 ), .B( n_1395 ), .A( n_1396 ) );
NAND3X1 (*
integer library_binding = "gsclib090";
 *)
i_559 ( .C(
n_1389 ), .Y( n_1391 ), .B( n_1392 ), .A( n_1393 ) );
NAND3X1 (*
integer library_binding = "gsclib090";
 *)
i_564 ( .C(
n_1386 ), .Y( n_1388 ), .B( n_1389 ), .A( n_1390 ) );
NAND3X1 (*
integer library_binding = "gsclib090";
 *)
i_569 ( .C(
n_1383 ), .Y( n_1385 ), .B( n_1386 ), .A( n_1387 ) );
NAND3X1 (*
integer library_binding = "gsclib090";
 *)
i_574 ( .C(
n_1380 ), .Y( n_1382 ), .B( n_1383 ), .A( n_1384 ) );
NAND3X1 (*
integer library_binding = "gsclib090";
 *)
i_579 ( .C(
n_1377 ), .Y( n_1379 ), .B( n_1380 ), .A( n_1381 ) );
NAND3X1 (*
integer library_binding = "gsclib090";
 *)
i_584 ( .C(
n_1374 ), .Y( n_1376 ), .B( n_1377 ), .A( n_1378 ) );
NAND3X1 (*
integer library_binding = "gsclib090";
 *)
i_589 ( .C(
n_1371 ), .Y( n_1373 ), .B( n_1374 ), .A( n_1375 ) );
NAND3X1 (*
integer library_binding = "gsclib090";
 *)
i_594 ( .C(
n_1368 ), .Y( n_1370 ), .B( n_1371 ), .A( n_1372 ) );
NAND3X1 (*
integer library_binding = "gsclib090";
 *)
i_599 ( .C(
n_1365 ), .Y( n_1367 ), .B( n_1368 ), .A( n_1369 ) );
NAND3X1 (*
integer library_binding = "gsclib090";
 *)
i_604 ( .C(
n_1361 ), .Y( n_1364 ), .B( n_1365 ), .A( n_1366 ) );
NAND3X1 (*
integer library_binding = "gsclib090";
 *)
i_750 ( .C(
n_1350 ), .Y( n_1352 ), .B( n_1353 ), .A( n_1354 ) );
NAND3X1 (*
integer library_binding = "gsclib090";
 *)
i_755 ( .C(
n_1347 ), .Y( n_1349 ), .B( n_1350 ), .A( n_1351 ) );
NAND3X1 (*
integer library_binding = "gsclib090";
 *)
i_760 ( .C(
n_1344 ), .Y( n_1346 ), .B( n_1347 ), .A( n_1348 ) );
NAND3X1 (*
integer library_binding = "gsclib090";
 *)
i_765 ( .C(
n_1341 ), .Y( n_1343 ), .B( n_1344 ), .A( n_1345 ) );
NAND3X1 (*
integer library_binding = "gsclib090";
 *)
i_770 ( .C(
n_1338 ), .Y( n_1340 ), .B( n_1341 ), .A( n_1342 ) );
NAND3X1 (*
integer library_binding = "gsclib090";
 *)
i_775 ( .C(
n_1335 ), .Y( n_1337 ), .B( n_1338 ), .A( n_1339 ) );
NAND3X1 (*
integer library_binding = "gsclib090";
 *)
i_780 ( .C(
n_1332 ), .Y( n_1334 ), .B( n_1335 ), .A( n_1336 ) );
NAND3X1 (*
integer library_binding = "gsclib090";
 *)
i_785 ( .C(
n_1329 ), .Y( n_1331 ), .B( n_1332 ), .A( n_1333 ) );
NAND3X1 (*
integer library_binding = "gsclib090";
 *)
i_790 ( .C(
n_1326 ), .Y( n_1328 ), .B( n_1329 ), .A( n_1330 ) );
NAND3X1 (*
integer library_binding = "gsclib090";
 *)
i_795 ( .C(
n_1323 ), .Y( n_1325 ), .B( n_1326 ), .A( n_1327 ) );
NAND3X1 (*
integer library_binding = "gsclib090";
 *)
i_800 ( .C(
n_1320 ), .Y( n_1322 ), .B( n_1323 ), .A( n_1324 ) );
NAND3X1 (*
integer library_binding = "gsclib090";
 *)
i_805 ( .C(
n_1317 ), .Y( n_1319 ), .B( n_1320 ), .A( n_1321 ) );
NAND3X1 (*
integer library_binding = "gsclib090";
 *)
i_810 ( .C(
n_1314 ), .Y( n_1316 ), .B( n_1317 ), .A( n_1318 ) );
NAND3X1 (*
integer library_binding = "gsclib090";
 *)
i_815 ( .C(
n_1311 ), .Y( n_1313 ), .B( n_1314 ), .A( n_1315 ) );
NAND3X1 (*
integer library_binding = "gsclib090";
 *)
i_820 ( .C(
n_1308 ), .Y( n_1310 ), .B( n_1311 ), .A( n_1312 ) );
NAND3X1 (*
integer library_binding = "gsclib090";
 *)
i_825 ( .C(
n_1305 ), .Y( n_1307 ), .B( n_1308 ), .A( n_1309 ) );
NAND3X1 (*
integer library_binding = "gsclib090";
 *)
i_830 ( .C(
n_1302 ), .Y( n_1304 ), .B( n_1305 ), .A( n_1306 ) );
NAND3X1 (*
integer library_binding = "gsclib090";
 *)
i_835 ( .C(
n_1299 ), .Y( n_1301 ), .B( n_1302 ), .A( n_1303 ) );
NAND3X1 (*
integer library_binding = "gsclib090";
 *)
i_840 ( .C(
n_1296 ), .Y( n_1298 ), .B( n_1299 ), .A( n_1300 ) );
NAND3X1 (*
integer library_binding = "gsclib090";
 *)
i_845 ( .C(
n_1293 ), .Y( n_1295 ), .B( n_1296 ), .A( n_1297 ) );
NAND3X1 (*
integer library_binding = "gsclib090";
 *)
i_850 ( .C(
n_1290 ), .Y( n_1292 ), .B( n_1293 ), .A( n_1294 ) );
NAND3X1 (*
integer library_binding = "gsclib090";
 *)
i_855 ( .C(
n_1287 ), .Y( n_1289 ), .B( n_1290 ), .A( n_1291 ) );
NAND3X1 (*
integer library_binding = "gsclib090";
 *)
i_860 ( .C(
n_1284 ), .Y( n_1286 ), .B( n_1287 ), .A( n_1288 ) );
NAND3X1 (*
integer library_binding = "gsclib090";
 *)
i_865 ( .C(
n_1281 ), .Y( n_1283 ), .B( n_1284 ), .A( n_1285 ) );
NAND3X1 (*
integer library_binding = "gsclib090";
 *)
i_870 ( .C(
n_1278 ), .Y( n_1280 ), .B( n_1281 ), .A( n_1282 ) );
NAND3X1 (*
integer library_binding = "gsclib090";
 *)
i_875 ( .C(
n_1275 ), .Y( n_1277 ), .B( n_1278 ), .A( n_1279 ) );
NAND3X1 (*
integer library_binding = "gsclib090";
 *)
i_880 ( .C(
n_1272 ), .Y( n_1274 ), .B( n_1275 ), .A( n_1276 ) );
NAND3X1 (*
integer library_binding = "gsclib090";
 *)
i_885 ( .C(
n_1269 ), .Y( n_1271 ), .B( n_1272 ), .A( n_1273 ) );
NAND3X1 (*
integer library_binding = "gsclib090";
 *)
i_890 ( .C(
n_1266 ), .Y( n_1268 ), .B( n_1269 ), .A( n_1270 ) );
NAND3X1 (*
integer library_binding = "gsclib090";
 *)
i_895 ( .C(
n_1263 ), .Y( n_1265 ), .B( n_1266 ), .A( n_1267 ) );
NAND3X1 (*
integer library_binding = "gsclib090";
 *)
i_900 ( .C(
n_1260 ), .Y( n_1262 ), .B( n_1263 ), .A( n_1264 ) );
NAND3X1 (*
integer library_binding = "gsclib090";
 *)
i_905 ( .C(
n_1257 ), .Y( n_1259 ), .B( n_1260 ), .A( n_1261 ) );
NAND3X1 (*
integer library_binding = "gsclib090";
 *)
i_910 ( .C(
n_1254 ), .Y( n_1256 ), .B( n_1257 ), .A( n_1258 ) );
NAND3X1 (*
integer library_binding = "gsclib090";
 *)
i_915 ( .C(
n_1251 ), .Y( n_1253 ), .B( n_1254 ), .A( n_1255 ) );
NAND3X1 (*
integer library_binding = "gsclib090";
 *)
i_920 ( .C(
n_1248 ), .Y( n_1250 ), .B( n_1251 ), .A( n_1252 ) );
NAND3X1 (*
integer library_binding = "gsclib090";
 *)
i_925 ( .C(
n_1245 ), .Y( n_1247 ), .B( n_1248 ), .A( n_1249 ) );
NAND3X1 (*
integer library_binding = "gsclib090";
 *)
i_930 ( .C(
n_1242 ), .Y( n_1244 ), .B( n_1245 ), .A( n_1246 ) );
NAND3X1 (*
integer library_binding = "gsclib090";
 *)
i_935 ( .C(
n_1239 ), .Y( n_1241 ), .B( n_1242 ), .A( n_1243 ) );
NAND3X1 (*
integer library_binding = "gsclib090";
 *)
i_940 ( .C(
n_1236 ), .Y( n_1238 ), .B( n_1239 ), .A( n_1240 ) );
NAND3X1 (*
integer library_binding = "gsclib090";
 *)
i_945 ( .C(
n_1233 ), .Y( n_1235 ), .B( n_1236 ), .A( n_1237 ) );
NAND3X1 (*
integer library_binding = "gsclib090";
 *)
i_950 ( .C(
n_1230 ), .Y( n_1232 ), .B( n_1233 ), .A( n_1234 ) );
NAND3X1 (*
integer library_binding = "gsclib090";
 *)
i_955 ( .C(
n_1227 ), .Y( n_1229 ), .B( n_1230 ), .A( n_1231 ) );
NAND3X1 (*
integer library_binding = "gsclib090";
 *)
i_960 ( .C(
n_1224 ), .Y( n_1226 ), .B( n_1227 ), .A( n_1228 ) );
NAND3X1 (*
integer library_binding = "gsclib090";
 *)
i_965 ( .C(
n_1221 ), .Y( n_1223 ), .B( n_1224 ), .A( n_1225 ) );
NAND3X1 (*
integer library_binding = "gsclib090";
 *)
i_970 ( .C(
n_1218 ), .Y( n_1220 ), .B( n_1221 ), .A( n_1222 ) );
NAND3X1 (*
integer library_binding = "gsclib090";
 *)
i_975 ( .C(
n_1215 ), .Y( n_1217 ), .B( n_1218 ), .A( n_1219 ) );
NAND3X1 (*
integer library_binding = "gsclib090";
 *)
i_980 ( .C(
n_1212 ), .Y( n_1214 ), .B( n_1215 ), .A( n_1216 ) );
NAND3X1 (*
integer library_binding = "gsclib090";
 *)
i_985 ( .C(
n_1209 ), .Y( n_1211 ), .B( n_1212 ), .A( n_1213 ) );
NAND3X1 (*
integer library_binding = "gsclib090";
 *)
i_990 ( .C(
n_1206 ), .Y( n_1208 ), .B( n_1209 ), .A( n_1210 ) );
NAND3X1 (*
integer library_binding = "gsclib090";
 *)
i_995 ( .C(
n_1203 ), .Y( n_1205 ), .B( n_1206 ), .A( n_1207 ) );
NAND3X1 (*
integer library_binding = "gsclib090";
 *)
i_1000 ( .C(
n_1200 ), .Y( n_1202 ), .B( n_1203 ), .A( n_1204 ) );
NAND3X1 (*
integer library_binding = "gsclib090";
 *)
i_1005 ( .C(
n_1197 ), .Y( n_1199 ), .B( n_1200 ), .A( n_1201 ) );
NAND3X1 (*
integer library_binding = "gsclib090";
 *)
i_1010 ( .C(
n_1194 ), .Y( n_1196 ), .B( n_1197 ), .A( n_1198 ) );
NAND3X1 (*
integer library_binding = "gsclib090";
 *)
i_1015 ( .C(
n_1191 ), .Y( n_1193 ), .B( n_1194 ), .A( n_1195 ) );
NAND3X1 (*
integer library_binding = "gsclib090";
 *)
i_1020 ( .C(
n_1188 ), .Y( n_1190 ), .B( n_1191 ), .A( n_1192 ) );
NAND3X1 (*
integer library_binding = "gsclib090";
 *)
i_1025 ( .C(
n_1185 ), .Y( n_1187 ), .B( n_1188 ), .A( n_1189 ) );
NAND3X1 (*
integer library_binding = "gsclib090";
 *)
i_1030 ( .C(
n_1181 ), .Y( n_1184 ), .B( n_1185 ), .A( n_1186 ) );
NAND3X1 (*
integer library_binding = "gsclib090";
 *)
i_9 ( .C( n_1355 ),
.Y( n_1164 ), .B( THERM[62] ), .A( THERM[61] ) );
NAND3X1 (*
integer library_binding = "gsclib090";
 *)
i_12450 ( .C(
n_1691 ), .Y( n_1155 ), .B( n_1352 ), .A( n_1355 ) );
NAND3X1 (*
integer library_binding = "gsclib090";
 *)
i_12490 ( .C(
n_1121 ), .Y( n_1132 ), .B( n_1337 ), .A( n_1340 ) );
NAND3X1 (*
integer library_binding = "gsclib090";
 *)
i_12498 ( .C(
n_1116 ), .Y( n_1128 ), .B( n_1334 ), .A( n_1337 ) );
NAND3X1 (*
integer library_binding = "gsclib090";
 *)
i_17502 ( .C(
n_1328 ), .Y( n_1125 ), .B( n_1322 ), .A( n_1325 ) );
NAND3X1 (*
integer library_binding = "gsclib090";
 *)
i_12514 ( .C(
n_1328 ), .Y( n_1118 ), .B( n_1107 ), .A( n_1331 ) );
NAND3X1 (*
integer library_binding = "gsclib090";
 *)
i_12522 ( .C(
n_1328 ), .Y( n_1113 ), .B( n_1102 ), .A( n_1325 ) );
NAND3X1 (*
integer library_binding = "gsclib090";
 *)
i_12530 ( .C(
n_1097 ), .Y( n_1109 ), .B( n_1322 ), .A( n_1325 ) );
NAND3X1 (*
integer library_binding = "gsclib090";
 *)
i_17534 ( .C(
n_1316 ), .Y( n_1106 ), .B( n_1310 ), .A( n_1313 ) );
NAND3X1 (*
integer library_binding = "gsclib090";
 *)
i_12546 ( .C(
n_1316 ), .Y( n_1099 ), .B( n_1088 ), .A( n_1319 ) );
NAND3X1 (*
integer library_binding = "gsclib090";
 *)
i_12554 ( .C(
n_1316 ), .Y( n_1094 ), .B( n_1083 ), .A( n_1313 ) );
NAND3X1 (*
integer library_binding = "gsclib090";
 *)
i_12562 ( .C(
n_1078 ), .Y( n_1090 ), .B( n_1310 ), .A( n_1313 ) );
NAND3X1 (*
integer library_binding = "gsclib090";
 *)
i_17566 ( .C(
n_1304 ), .Y( n_1087 ), .B( n_1298 ), .A( n_1301 ) );
NAND3X1 (*
integer library_binding = "gsclib090";
 *)
i_12578 ( .C(
n_1304 ), .Y( n_1080 ), .B( n_1069 ), .A( n_1307 ) );
NAND3X1 (*
integer library_binding = "gsclib090";
 *)
i_12586 ( .C(
n_1304 ), .Y( n_1075 ), .B( n_1064 ), .A( n_1301 ) );
NAND3X1 (*
integer library_binding = "gsclib090";
 *)
i_12594 ( .C(
n_1059 ), .Y( n_1071 ), .B( n_1298 ), .A( n_1301 ) );
NAND3X1 (*
integer library_binding = "gsclib090";
 *)
i_17598 ( .C(
n_1292 ), .Y( n_1068 ), .B( n_1286 ), .A( n_1289 ) );
NAND3X1 (*
integer library_binding = "gsclib090";
 *)
i_12610 ( .C(
n_1292 ), .Y( n_1061 ), .B( n_1050 ), .A( n_1295 ) );
NAND3X1 (*
integer library_binding = "gsclib090";
 *)
i_12618 ( .C(
n_1292 ), .Y( n_1056 ), .B( n_1045 ), .A( n_1289 ) );
NAND3X1 (*
integer library_binding = "gsclib090";
 *)
i_12626 ( .C(
n_1040 ), .Y( n_1052 ), .B( n_1286 ), .A( n_1289 ) );
NAND3X1 (*
integer library_binding = "gsclib090";
 *)
i_17630 ( .C(
n_1280 ), .Y( n_1049 ), .B( n_1274 ), .A( n_1277 ) );
NAND3X1 (*
integer library_binding = "gsclib090";
 *)
i_287 ( .C(
n_673 ), .Y( n_669 ), .B( n_672 ), .A( n_671 ) );
NAND3X1 (*
integer library_binding = "gsclib090";
 *)
i_169 ( .C(
n_752 ), .Y( n_748 ), .B( n_751 ), .A( n_750 ) );
NAND3X1 (*
integer library_binding = "gsclib090";
 *)
i_124 ( .C(
n_782 ), .Y( n_778 ), .B( n_781 ), .A( n_780 ) );
NAND3X1 (*
integer library_binding = "gsclib090";
 *)
i_74 ( .C(
n_1693 ), .Y( n_826 ), .B( n_1161 ), .A( n_1543 ) );
NAND3X1 (*
integer library_binding = "gsclib090";
 *)
i_12890 ( .C(
n_886 ), .Y( n_892 ), .B( n_1187 ), .A( n_1190 ) );
NAND3X1 (*
integer library_binding = "gsclib090";
 *)
i_12874 ( .C(
n_890 ), .Y( n_903 ), .B( n_1193 ), .A( n_1196 ) );
NAND3X1 (*
integer library_binding = "gsclib090";
 *)
i_12866 ( .C(
n_895 ), .Y( n_909 ), .B( n_1196 ), .A( n_1199 ) );
NAND3X1 (*
integer library_binding = "gsclib090";
 *)
i_12858 ( .C(
n_914 ), .Y( n_915 ), .B( n_1199 ), .A( n_1202 ) );
NAND3X1 (*
integer library_binding = "gsclib090";
 *)
i_12850 ( .C(
n_907 ), .Y( n_919 ), .B( n_1202 ), .A( n_1205 ) );
NAND3X1 (*
integer library_binding = "gsclib090";
 *)
i_12842 ( .C(
n_912 ), .Y( n_923 ), .B( n_1205 ), .A( n_1208 ) );
NAND3X1 (*
integer library_binding = "gsclib090";
 *)
i_12834 ( .C(
n_917 ), .Y( n_928 ), .B( n_1208 ), .A( n_1211 ) );
NAND3X1 (*
integer library_binding = "gsclib090";
 *)
i_17822 ( .C(
n_1208 ), .Y( n_935 ), .B( n_1202 ), .A( n_1205 ) );
NAND3X1 (*
integer library_binding = "gsclib090";
 *)
i_12818 ( .C(
n_1217 ), .Y( n_938 ), .B( n_926 ), .A( n_1214 ) );
NAND3X1 (*
integer library_binding = "gsclib090";
 *)
i_12810 ( .C(
n_1217 ), .Y( n_942 ), .B( n_1220 ), .A( n_931 ) );
NAND3X1 (*
integer library_binding = "gsclib090";
 *)
i_12802 ( .C(
n_1220 ), .Y( n_947 ), .B( n_936 ), .A( n_1223 ) );
NAND3X1 (*
integer library_binding = "gsclib090";
 *)
i_12786 ( .C(
n_945 ), .Y( n_957 ), .B( n_1226 ), .A( n_1229 ) );
NAND3X1 (*
integer library_binding = "gsclib090";
 *)
i_12778 ( .C(
n_950 ), .Y( n_961 ), .B( n_1229 ), .A( n_1232 ) );
NAND3X1 (*
integer library_binding = "gsclib090";
 *)
i_12770 ( .C(
n_955 ), .Y( n_966 ), .B( n_1232 ), .A( n_1235 ) );
NAND3X1 (*
integer library_binding = "gsclib090";
 *)
i_17758 ( .C(
n_1232 ), .Y( n_973 ), .B( n_1226 ), .A( n_1229 ) );
NAND3X1 (*
integer library_binding = "gsclib090";
 *)
i_12754 ( .C(
n_964 ), .Y( n_976 ), .B( n_1238 ), .A( n_1241 ) );
NAND3X1 (*
integer library_binding = "gsclib090";
 *)
i_12746 ( .C(
n_1244 ), .Y( n_980 ), .B( n_969 ), .A( n_1241 ) );
NAND3X1 (*
integer library_binding = "gsclib090";
 *)
i_12738 ( .C(
n_1244 ), .Y( n_985 ), .B( n_974 ), .A( n_1247 ) );
NAND3X1 (*
integer library_binding = "gsclib090";
 *)
i_17726 ( .C(
n_1244 ), .Y( n_992 ), .B( n_1238 ), .A( n_1241 ) );
NAND3X1 (*
integer library_binding = "gsclib090";
 *)
i_12722 ( .C(
n_983 ), .Y( n_995 ), .B( n_1250 ), .A( n_1253 ) );
NAND3X1 (*
integer library_binding = "gsclib090";
 *)
i_12714 ( .C(
n_1256 ), .Y( n_999 ), .B( n_988 ), .A( n_1253 ) );
NAND3X1 (*
integer library_binding = "gsclib090";
 *)
i_12706 ( .C(
n_1256 ), .Y( n_1004 ), .B( n_993 ), .A( n_1259 ) );
NAND3X1 (*
integer library_binding = "gsclib090";
 *)
i_17694 ( .C(
n_1256 ), .Y( n_1011 ), .B( n_1250 ), .A( n_1253 ) );
NAND3X1 (*
integer library_binding = "gsclib090";
 *)
i_12690 ( .C(
n_1002 ), .Y( n_1014 ), .B( n_1262 ), .A( n_1265 ) );
NAND3X1 (*
integer library_binding = "gsclib090";
 *)
i_12682 ( .C(
n_1268 ), .Y( n_1018 ), .B( n_1007 ), .A( n_1265 ) );
NAND3X1 (*
integer library_binding = "gsclib090";
 *)
i_12674 ( .C(
n_1268 ), .Y( n_1023 ), .B( n_1012 ), .A( n_1271 ) );
NAND3X1 (*
integer library_binding = "gsclib090";
 *)
i_17662 ( .C(
n_1268 ), .Y( n_1030 ), .B( n_1262 ), .A( n_1265 ) );
NAND3X1 (*
integer library_binding = "gsclib090";
 *)
i_12658 ( .C(
n_1021 ), .Y( n_1033 ), .B( n_1274 ), .A( n_1277 ) );
NAND3X1 (*
integer library_binding = "gsclib090";
 *)
i_12650 ( .C(
n_1280 ), .Y( n_1037 ), .B( n_1026 ), .A( n_1277 ) );
NAND3X1 (*
integer library_binding = "gsclib090";
 *)
i_12642 ( .C(
n_1280 ), .Y( n_1042 ), .B( n_1031 ), .A( n_1283 ) );

NOR2X1 (*
integer library_binding = "gsclib090";
 *)
i_19463 ( .Y(
n_1549 ), .B( n_1147 ), .A( n_1349 ) );
NOR2X1 (*
integer library_binding = "gsclib090";
 *)
i_1 ( .Y( n_1177 ),
.B( n_669 ), .A( n_662 ) );
NOR2X1 (*
integer library_binding = "gsclib090";
 *)
i_10 ( .Y( n_1176 ),
.B( n_748 ), .A( n_741 ) );
NOR2X1 (*
integer library_binding = "gsclib090";
 *)
i_21 ( .Y( n_1175 ),
.B( n_704 ), .A( n_698 ) );
NOR2X1 (*
integer library_binding = "gsclib090";
 *)
i_16 ( .Y( n_1172 ),
.B( n_809 ), .A( n_802 ) );
NOR2X1 (*
integer library_binding = "gsclib090";
 *)
i_5429 ( .Y(
n_1165 ), .B( THERM[0] ), .A( THERM[1] ) );
NOR2X1 (*
integer library_binding = "gsclib090";
 *)
i_10465 ( .Y(
n_1145 ), .B( n_1692 ), .A( n_1691 ) );
NOR2X1 (*
integer library_binding = "gsclib090";
 *)
i_15469 ( .Y(
n_1144 ), .B( n_1346 ), .A( n_1349 ) );
NOR2X1 (*
integer library_binding = "gsclib090";
 *)
i_15485 ( .Y(
n_1135 ), .B( n_1340 ), .A( n_1343 ) );
NOR2X1 (*
integer library_binding = "gsclib090";
 *)
i_14484 ( .Y(
n_1134 ), .B( n_1689 ), .A( n_1337 ) );
NOR2X1 (*
integer library_binding = "gsclib090";
 *)
i_15509 ( .Y(
n_1121 ), .B( n_1334 ), .A( n_1331 ) );
NOR2X1 (*
integer library_binding = "gsclib090";
 *)
i_15517 ( .Y(
n_1116 ), .B( n_1328 ), .A( n_1331 ) );
NOR2X1 (*
integer library_binding = "gsclib090";
 *)
i_14516 ( .Y(
n_1115 ), .B( n_1682 ), .A( n_1325 ) );
NOR2X1 (*
integer library_binding = "gsclib090";
 *)
i_15533 ( .Y(
n_1107 ), .B( n_1322 ), .A( n_1325 ) );
NOR2X1 (*
integer library_binding = "gsclib090";
 *)
i_15541 ( .Y(
n_1102 ), .B( n_1322 ), .A( n_1319 ) );
NOR2X1 (*
integer library_binding = "gsclib090";
 *)
i_15549 ( .Y(
n_1097 ), .B( n_1316 ), .A( n_1319 ) );
NOR2X1 (*
integer library_binding = "gsclib090";
 *)
i_14548 ( .Y(
n_1096 ), .B( n_1687 ), .A( n_1313 ) );
NOR2X1 (*
integer library_binding = "gsclib090";
 *)
i_15565 ( .Y(
n_1088 ), .B( n_1310 ), .A( n_1313 ) );
NOR2X1 (*
integer library_binding = "gsclib090";
 *)
i_15573 ( .Y(
n_1083 ), .B( n_1310 ), .A( n_1307 ) );
NOR2X1 (*
integer library_binding = "gsclib090";
 *)
i_15581 ( .Y(
n_1078 ), .B( n_1304 ), .A( n_1307 ) );
NOR2X1 (*
integer library_binding = "gsclib090";
 *)
i_14580 ( .Y(
n_1077 ), .B( n_1680 ), .A( n_1301 ) );
NOR2X1 (*
integer library_binding = "gsclib090";
 *)
i_15597 ( .Y(
n_1069 ), .B( n_1298 ), .A( n_1301 ) );
NOR2X1 (*
integer library_binding = "gsclib090";
 *)
i_15605 ( .Y(
n_1064 ), .B( n_1298 ), .A( n_1295 ) );
NOR2X1 (*
integer library_binding = "gsclib090";
 *)
i_15613 ( .Y(
n_1059 ), .B( n_1292 ), .A( n_1295 ) );
NOR2X1 (*
integer library_binding = "gsclib090";
 *)
i_14612 ( .Y(
n_1058 ), .B( n_1674 ), .A( n_1289 ) );
NOR2X1 (*
integer library_binding = "gsclib090";
 *)
i_15629 ( .Y(
n_1050 ), .B( n_1286 ), .A( n_1289 ) );
NOR2X1 (*
integer library_binding = "gsclib090";
 *)
i_295 ( .Y( n_664 ),
.B( n_1570 ), .A( n_1568 ) );
NOR2X1 (*
integer library_binding = "gsclib090";
 *)
i_293 ( .Y( n_665 ),
.B( n_1572 ), .A( n_1574 ) );
NOR2X1 (*
integer library_binding = "gsclib090";
 *)
i_290 ( .Y( n_667 ),
.B( n_1576 ), .A( n_1578 ) );
NOR2X1 (*
integer library_binding = "gsclib090";
 *)
i_289 ( .Y( n_668 ),
.B( n_1580 ), .A( n_1582 ) );
NOR2X1 (*
integer library_binding = "gsclib090";
 *)
i_284 ( .Y( n_671 ),
.B( n_1584 ), .A( n_1586 ) );
NOR2X1 (*
integer library_binding = "gsclib090";
 *)
i_283 ( .Y( n_672 ),
.B( n_1588 ), .A( n_1590 ) );
NOR2X1 (*
integer library_binding = "gsclib090";
 *)
i_281 ( .Y( n_673 ),
.B( n_675 ), .A( n_674 ) );
NOR2X1 (*
integer library_binding = "gsclib090";
 *)
i_241 ( .Y( n_700 ),
.B( n_1564 ), .A( n_1566 ) );
NOR2X1 (*
integer library_binding = "gsclib090";
 *)
i_239 ( .Y( n_701 ),
.B( n_1560 ), .A( n_1562 ) );
NOR2X1 (*
integer library_binding = "gsclib090";
 *)
i_236 ( .Y( n_703 ),
.B( n_1556 ), .A( n_1558 ) );
NOR2X1 (*
integer library_binding = "gsclib090";
 *)
i_232 ( .Y( n_706 ),
.B( n_1552 ), .A( n_1550 ) );
NOR2X1 (*
integer library_binding = "gsclib090";
 *)
i_229 ( .Y( n_708 ),
.B( n_1544 ), .A( n_1546 ) );
NOR2X1 (*
integer library_binding = "gsclib090";
 *)
i_176 ( .Y( n_743 ),
.B( n_1600 ), .A( n_1602 ) );
NOR2X1 (*
integer library_binding = "gsclib090";
 *)
i_175 ( .Y( n_744 ),
.B( n_1604 ), .A( n_1606 ) );
NOR2X1 (*
integer library_binding = "gsclib090";
 *)
i_172 ( .Y( n_746 ),
.B( n_1608 ), .A( n_1610 ) );
NOR2X1 (*
integer library_binding = "gsclib090";
 *)
i_170 ( .Y( n_747 ),
.B( n_1612 ), .A( n_1614 ) );
NOR2X1 (*
integer library_binding = "gsclib090";
 *)
i_166 ( .Y( n_750 ),
.B( n_1616 ), .A( n_1618 ) );
NOR2X1 (*
integer library_binding = "gsclib090";
 *)
i_164 ( .Y( n_751 ),
.B( n_1620 ), .A( n_1622 ) );
NOR2X1 (*
integer library_binding = "gsclib090";
 *)
i_163 ( .Y( n_752 ),
.B( n_754 ), .A( n_753 ) );
NOR2X1 (*
integer library_binding = "gsclib090";
 *)
i_121 ( .Y( n_780 ),
.B( n_1632 ), .A( n_1634 ) );
NOR2X1 (*
integer library_binding = "gsclib090";
 *)
i_120 ( .Y( n_781 ),
.B( n_1636 ), .A( n_1638 ) );
NOR2X1 (*
integer library_binding = "gsclib090";
 *)
i_107 ( .Y( n_793 ),
.B( n_1550 ), .A( n_1568 ) );
NOR2X1 (*
integer library_binding = "gsclib090";
 *)
i_86 ( .Y( n_814 ),
.B( n_1648 ), .A( n_1650 ) );
NOR2X1 (*
integer library_binding = "gsclib090";
 *)
i_85 ( .Y( n_815 ),
.B( n_1652 ), .A( n_1654 ) );
NOR2X1 (*
integer library_binding = "gsclib090";
 *)
i_84 ( .Y( n_816 ),
.B( n_820 ), .A( n_817 ) );
NOR2X1 (*
integer library_binding = "gsclib090";
 *)
i_78 ( .Y( n_822 ),
.B( n_826 ), .A( n_823 ) );
NOR2X1 (*
integer library_binding = "gsclib090";
 *)
i_66 ( .Y( n_834 ),
.B( n_1624 ), .A( n_1626 ) );
NOR2X1 (*
integer library_binding = "gsclib090";
 *)
i_56 ( .Y( n_844 ),
.B( n_1592 ), .A( n_1594 ) );
NOR2X1 (*
integer library_binding = "gsclib090";
 *)
i_48 ( .Y( n_852 ),
.B( n_1552 ), .A( n_1554 ) );
NOR2X1 (*
integer library_binding = "gsclib090";
 *)
i_42 ( .Y( n_858 ),
.B( n_1718 ), .A( n_1652 ) );
NOR2X1 (*
integer library_binding = "gsclib090";
 *)
i_41 ( .Y( n_859 ),
.B( n_1648 ), .A( n_1644 ) );
NOR2X1 (*
integer library_binding = "gsclib090";
 *)
i_39 ( .Y( n_861 ),
.B( n_1640 ), .A( n_1636 ) );
NOR2X1 (*
integer library_binding = "gsclib090";
 *)
i_37 ( .Y( n_862 ),
.B( n_1632 ), .A( n_1628 ) );
NOR2X1 (*
integer library_binding = "gsclib090";
 *)
i_33 ( .Y( n_865 ),
.B( n_1624 ), .A( n_1620 ) );
NOR2X1 (*
integer library_binding = "gsclib090";
 *)
i_31 ( .Y( n_866 ),
.B( n_1616 ), .A( n_1612 ) );
NOR2X1 (*
integer library_binding = "gsclib090";
 *)
i_29 ( .Y( n_868 ),
.B( n_1608 ), .A( n_1604 ) );
NOR2X1 (*
integer library_binding = "gsclib090";
 *)
i_28 ( .Y( n_869 ),
.B( n_1600 ), .A( n_884 ) );
NOR2X1 (*
integer library_binding = "gsclib090";
 *)
i_23 ( .Y( n_872 ),
.B( n_1596 ), .A( n_1592 ) );
NOR2X1 (*
integer library_binding = "gsclib090";
 *)
i_22 ( .Y( n_873 ),
.B( n_1588 ), .A( n_1584 ) );
NOR2X1 (*
integer library_binding = "gsclib090";
 *)
i_18 ( .Y( n_875 ),
.B( n_1580 ), .A( n_1576 ) );
NOR2X1 (*
integer library_binding = "gsclib090";
 *)
i_15 ( .Y( n_876 ),
.B( n_1572 ), .A( n_1568 ) );
NOR2X1 (*
integer library_binding = "gsclib090";
 *)
i_9903 ( .Y(
n_884 ), .B( n_1717 ), .A( n_1165 ) );
NOR2X1 (*
integer library_binding = "gsclib090";
 *)
i_12900 ( .Y(
n_886 ), .B( n_1180 ), .A( n_1184 ) );
NOR2X1 (*
integer library_binding = "gsclib090";
 *)
i_9896 ( .Y(
n_887 ), .B( n_1180 ), .A( n_1717 ) );
NOR2X1 (*
integer library_binding = "gsclib090";
 *)
i_14892 ( .Y(
n_889 ), .B( n_1716 ), .A( n_1184 ) );
NOR2X1 (*
integer library_binding = "gsclib090";
 *)
i_15893 ( .Y(
n_890 ), .B( n_1187 ), .A( n_1190 ) );
NOR2X1 (*
integer library_binding = "gsclib090";
 *)
i_15885 ( .Y(
n_895 ), .B( n_1193 ), .A( n_1190 ) );
NOR2X1 (*
integer library_binding = "gsclib090";
 *)
i_15869 ( .Y(
n_907 ), .B( n_1196 ), .A( n_1199 ) );
NOR2X1 (*
integer library_binding = "gsclib090";
 *)
i_14860 ( .Y(
n_911 ), .B( n_1714 ), .A( n_1196 ) );
NOR2X1 (*
integer library_binding = "gsclib090";
 *)
i_15861 ( .Y(
n_912 ), .B( n_1202 ), .A( n_1199 ) );
NOR2X1 (*
integer library_binding = "gsclib090";
 *)
i_9856 ( .Y(
n_914 ), .B( n_1193 ), .A( n_1196 ) );
NOR2X1 (*
integer library_binding = "gsclib090";
 *)
i_15853 ( .Y(
n_917 ), .B( n_1202 ), .A( n_1205 ) );
NOR2X1 (*
integer library_binding = "gsclib090";
 *)
i_14836 ( .Y(
n_925 ), .B( n_1205 ), .A( n_1711 ) );
NOR2X1 (*
integer library_binding = "gsclib090";
 *)
i_15837 ( .Y(
n_926 ), .B( n_1208 ), .A( n_1211 ) );
NOR2X1 (*
integer library_binding = "gsclib090";
 *)
i_14828 ( .Y(
n_930 ), .B( n_1710 ), .A( n_1208 ) );
NOR2X1 (*
integer library_binding = "gsclib090";
 *)
i_15829 ( .Y(
n_931 ), .B( n_1214 ), .A( n_1211 ) );
NOR2X1 (*
integer library_binding = "gsclib090";
 *)
i_15821 ( .Y(
n_936 ), .B( n_1214 ), .A( n_1217 ) );
NOR2X1 (*
integer library_binding = "gsclib090";
 *)
i_14804 ( .Y(
n_944 ), .B( n_1217 ), .A( n_1708 ) );
NOR2X1 (*
integer library_binding = "gsclib090";
 *)
i_15805 ( .Y(
n_945 ), .B( n_1220 ), .A( n_1223 ) );
NOR2X1 (*
integer library_binding = "gsclib090";
 *)
i_15797 ( .Y(
n_950 ), .B( n_1226 ), .A( n_1223 ) );
NOR2X1 (*
integer library_binding = "gsclib090";
 *)
i_15789 ( .Y(
n_955 ), .B( n_1226 ), .A( n_1229 ) );
NOR2X1 (*
integer library_binding = "gsclib090";
 *)
i_14772 ( .Y(
n_963 ), .B( n_1229 ), .A( n_1705 ) );
NOR2X1 (*
integer library_binding = "gsclib090";
 *)
i_15773 ( .Y(
n_964 ), .B( n_1232 ), .A( n_1235 ) );
NOR2X1 (*
integer library_binding = "gsclib090";
 *)
i_14764 ( .Y(
n_968 ), .B( n_1704 ), .A( n_1232 ) );
NOR2X1 (*
integer library_binding = "gsclib090";
 *)
i_15765 ( .Y(
n_969 ), .B( n_1238 ), .A( n_1235 ) );
NOR2X1 (*
integer library_binding = "gsclib090";
 *)
i_15757 ( .Y(
n_974 ), .B( n_1238 ), .A( n_1241 ) );
NOR2X1 (*
integer library_binding = "gsclib090";
 *)
i_14740 ( .Y(
n_982 ), .B( n_1702 ), .A( n_1241 ) );
NOR2X1 (*
integer library_binding = "gsclib090";
 *)
i_15741 ( .Y(
n_983 ), .B( n_1244 ), .A( n_1247 ) );
NOR2X1 (*
integer library_binding = "gsclib090";
 *)
i_15733 ( .Y(
n_988 ), .B( n_1250 ), .A( n_1247 ) );
NOR2X1 (*
integer library_binding = "gsclib090";
 *)
i_15725 ( .Y(
n_993 ), .B( n_1250 ), .A( n_1253 ) );
NOR2X1 (*
integer library_binding = "gsclib090";
 *)
i_14708 ( .Y(
n_1001 ), .B( n_1699 ), .A( n_1253 ) );
NOR2X1 (*
integer library_binding = "gsclib090";
 *)
i_15709 ( .Y(
n_1002 ), .B( n_1256 ), .A( n_1259 ) );
NOR2X1 (*
integer library_binding = "gsclib090";
 *)
i_15701 ( .Y(
n_1007 ), .B( n_1262 ), .A( n_1259 ) );
NOR2X1 (*
integer library_binding = "gsclib090";
 *)
i_15693 ( .Y(
n_1012 ), .B( n_1262 ), .A( n_1265 ) );
NOR2X1 (*
integer library_binding = "gsclib090";
 *)
i_14676 ( .Y(
n_1020 ), .B( n_1679 ), .A( n_1265 ) );
NOR2X1 (*
integer library_binding = "gsclib090";
 *)
i_15677 ( .Y(
n_1021 ), .B( n_1268 ), .A( n_1271 ) );
NOR2X1 (*
integer library_binding = "gsclib090";
 *)
i_15669 ( .Y(
n_1026 ), .B( n_1274 ), .A( n_1271 ) );
NOR2X1 (*
integer library_binding = "gsclib090";
 *)
i_15661 ( .Y(
n_1031 ), .B( n_1274 ), .A( n_1277 ) );
NOR2X1 (*
integer library_binding = "gsclib090";
 *)
i_14644 ( .Y(
n_1039 ), .B( n_1673 ), .A( n_1277 ) );
NOR2X1 (*
integer library_binding = "gsclib090";
 *)
i_15645 ( .Y(
n_1040 ), .B( n_1280 ), .A( n_1283 ) );
NOR2X1 (*
integer library_binding = "gsclib090";
 *)
i_15637 ( .Y(
n_1045 ), .B( n_1286 ), .A( n_1283 ) );

endmodule
