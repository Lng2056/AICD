// Verilog-AMS netlist generated by the AMS netlister, version ICOA5.2.51.500.7.
// Cadence Design Systems, Inc.

`include "disciplines.vams"

module clkbuffers2X ( in,out );

input [10:0]  in;
output [10:0]  out;

wire [0:10] net15;
wire [0:10] net11;
wire [0:10] net9;

inv_16x_hv #(.d2a_tr("100p"), .ieIO("output"), .a2d_v0("0.5"), .d2a_tf("100p"),
 .a2d_v1("0.8"), .a2d_tx("100p"), .d2a_vh("2.5")) (*
integer
library_binding = "ether";
integer elaboration_binding = "I3[10:0]";

 *)
I3_10 ( .Y( out[10] ), .A( net11[0] ) ),
  I3_9 ( .Y( out[9] ), .A( net11[1] ) ),
  I3_8 ( .Y( out[8] ), .A( net11[2] ) ),
  I3_7 ( .Y( out[7] ), .A( net11[3] ) ),
  I3_6 ( .Y( out[6] ), .A( net11[4] ) ),
  I3_5 ( .Y( out[5] ), .A( net11[5] ) ),
  I3_4 ( .Y( out[4] ), .A( net11[6] ) ),
  I3_3 ( .Y( out[3] ), .A( net11[7] ) ),
  I3_2 ( .Y( out[2] ), .A( net11[8] ) ),
  I3_1 ( .Y( out[1] ), .A( net11[9] ) ),
  I3_0 ( .Y( out[0] ), .A( net11[10] ) );
inv_16x_hv #(.d2a_tr("100p"), .ieIO("output"), .a2d_v0("0.5"), .d2a_tf("100p"),
 .a2d_v1("0.8"), .a2d_tx("100p"), .d2a_vh("2.5")) (*
integer
library_binding = "ether";
integer elaboration_binding = "I5[10:0]";

 *)
I5_10 ( .Y( out[10] ), .A( net11[0] ) ),
  I5_9 ( .Y( out[9] ), .A( net11[1] ) ),
  I5_8 ( .Y( out[8] ), .A( net11[2] ) ),
  I5_7 ( .Y( out[7] ), .A( net11[3] ) ),
  I5_6 ( .Y( out[6] ), .A( net11[4] ) ),
  I5_5 ( .Y( out[5] ), .A( net11[5] ) ),
  I5_4 ( .Y( out[4] ), .A( net11[6] ) ),
  I5_3 ( .Y( out[3] ), .A( net11[7] ) ),
  I5_2 ( .Y( out[2] ), .A( net11[8] ) ),
  I5_1 ( .Y( out[1] ), .A( net11[9] ) ),
  I5_0 ( .Y( out[0] ), .A( net11[10] ) );

inv_8x_hv #(.d2a_tr("100p"), .ieIO("output"), .a2d_v0("0.5"), .d2a_tf("100p"),
 .a2d_v1("0.8"), .a2d_tx("100p"), .d2a_vh("2.5")) (*
integer
library_binding = "ether";
integer elaboration_binding = "I4[10:0]";

 *)
I4_10 ( .Y( net11[0] ), .A( net9[0] ) ),
  I4_9 ( .Y( net11[1] ), .A( net9[1] ) ),
  I4_8 ( .Y( net11[2] ), .A( net9[2] ) ),
  I4_7 ( .Y( net11[3] ), .A( net9[3] ) ),
  I4_6 ( .Y( net11[4] ), .A( net9[4] ) ),
  I4_5 ( .Y( net11[5] ), .A( net9[5] ) ),
  I4_4 ( .Y( net11[6] ), .A( net9[6] ) ),
  I4_3 ( .Y( net11[7] ), .A( net9[7] ) ),
  I4_2 ( .Y( net11[8] ), .A( net9[8] ) ),
  I4_1 ( .Y( net11[9] ), .A( net9[9] ) ),
  I4_0 ( .Y( net11[10] ), .A( net9[10] ) );

inv_3x_hv #(.d2a_tr("100p"), .ieIO("output"), .a2d_v0("0.5"), .d2a_tf("100p"),
 .a2d_v1("0.8"), .a2d_tx("100p"), .d2a_vh("2.5")) (*
integer
library_binding = "ether";
integer elaboration_binding = "I1[10:0]";

 *)
I1_10 ( .Y( net9[0] ), .A( net15[0] ) ),
  I1_9 ( .Y( net9[1] ), .A( net15[1] ) ),
  I1_8 ( .Y( net9[2] ), .A( net15[2] ) ),
  I1_7 ( .Y( net9[3] ), .A( net15[3] ) ),
  I1_6 ( .Y( net9[4] ), .A( net15[4] ) ),
  I1_5 ( .Y( net9[5] ), .A( net15[5] ) ),
  I1_4 ( .Y( net9[6] ), .A( net15[6] ) ),
  I1_3 ( .Y( net9[7] ), .A( net15[7] ) ),
  I1_2 ( .Y( net9[8] ), .A( net15[8] ) ),
  I1_1 ( .Y( net9[9] ), .A( net15[9] ) ),
  I1_0 ( .Y( net9[10] ), .A( net15[10] ) );

inv_1x_hv #(.d2a_tr("100p"), .ieIO("input"), .a2d_v0("0.5"), .d2a_tf("100p"),
 .a2d_tx("100p"), .d2a_vh("2.5"), .a2d_v1("0.8")) (*
integer
library_binding = "ether";
integer elaboration_binding = "I71[10:0]";

 *)
I71_10 ( .Y( net15[0] ), .A( in[10] ) ),
  I71_9 ( .Y( net15[1] ), .A( in[9] ) ),
  I71_8 ( .Y( net15[2] ), .A( in[8] ) ),
  I71_7 ( .Y( net15[3] ), .A( in[7] ) ),
  I71_6 ( .Y( net15[4] ), .A( in[6] ) ),
  I71_5 ( .Y( net15[5] ), .A( in[5] ) ),
  I71_4 ( .Y( net15[6] ), .A( in[4] ) ),
  I71_3 ( .Y( net15[7] ), .A( in[3] ) ),
  I71_2 ( .Y( net15[8] ), .A( in[2] ) ),
  I71_1 ( .Y( net15[9] ), .A( in[1] ) ),
  I71_0 ( .Y( net15[10] ), .A( in[0] ) );

endmodule
