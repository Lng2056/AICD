// Verilog-AMS netlist generated by the AMS netlister, version ICOA5.2.51.500.7.
// Cadence Design Systems, Inc.

`include "disciplines.vams"

module PLL_PDVR ( VREF,IPLY_25u,UPn,VDD,UP,PD,VSS,UPp,FB_IN,FB_OUT );

output   VREF;
input   IPLY_25u;
output   UPn;
input   VDD;
input
 UP;
input   PD;
input   VSS;
output   UPp;
input   FB_IN;
output
 FB_OUT;

gpdk090_resnsppoly #(.w(2u), .r(998.378), .l(4.98429u)) (*
integer
library_binding = "gpdk090";
 *)
R2 ( net096, VDD, VSS );
gpdk090_resnsppoly #(.w(2u), .r(9.49866K), .l(47.4829u)) (*
integer
library_binding = "gpdk090";
 *)
R20 ( FB_OUT, VDD, VSS );
gpdk090_resnsppoly #(.w(2u), .r(1.99973K), .l(9.985u)) (*
integer
library_binding = "gpdk090";
 *)
R3 ( VDD, net117, VSS );
gpdk090_resnsppoly #(.w(2u), .r(1.59974K), .l(7.985u)) (*
integer
library_binding = "gpdk090";
 *)
R17 ( net108, VREF, VSS );
gpdk090_resnsppoly #(.w(2u), .r(1.59974K), .l(7.985u)) (*
integer
library_binding = "gpdk090";
 *)
R13 ( net117, UPn, VSS );
gpdk090_resnsppoly #(.w(2u), .r(1.59974K), .l(7.985u)) (*
integer
library_binding = "gpdk090";
 *)
R12 ( net117, UPp, VSS );
gpdk090_resnsppoly #(.w(2u), .r(1.99973K), .l(9.985u)) (*
integer
library_binding = "gpdk090";
 *)
R4 ( VDD, net108, VSS );

gpdk090_nmos2v #(.ps(3.2u), .m(1 * 1), .as(600f), .l(280.0n), .pd(3.2u),
 .ad(600f), .w(1u)) (*
integer library_binding = "gpdk090";
integer
passed_mfactor = "m";
 *)
NM18 ( net78, SLEEP, VSS, VSS );
gpdk090_nmos2v #(.ps(21.2u), .m(1 * 2), .as(6p), .l(1u), .pd(10.6u), .ad(3p),
 .w(10u)) (*
integer library_binding = "gpdk090";
integer
passed_mfactor = "m";
 *)
NM17 ( FB_OUT, net78, VSS, VSS );
gpdk090_nmos2v #(.ps(21.2u), .m(1 * 2), .as(6p), .l(1u), .pd(10.6u), .ad(3p),
 .w(10u)) (*
integer library_binding = "gpdk090";
integer
passed_mfactor = "m";
 *)
NM20 ( net78, net78, VSS, VSS );
gpdk090_nmos2v #(.ps(13.25u), .m(1 * 8), .as(3.75p), .l(1u), .pd(10.6u),
 .ad(3p), .w(10u)) (*
integer library_binding = "gpdk090";
integer
passed_mfactor = "m";
 *)
NM21 ( net80, net78, VSS, VSS );
gpdk090_nmos2v #(.ps(13.25u), .m(1 * 8), .as(3.75p), .l(1u), .pd(10.6u),
 .ad(3p), .w(10u)) (*
integer library_binding = "gpdk090";
integer
passed_mfactor = "m";
 *)
NM13 ( net99, net78, VSS, VSS );
gpdk090_nmos2v #(.ps(19.2u), .m(1 * 2), .as(5.4p), .l(280.0n), .pd(9.6u),
 .ad(2.7p), .w(9u)) (*
integer library_binding = "gpdk090";
integer
passed_mfactor = "m";
 *)
NM12 ( UPn, s1b, net99, VSS );
gpdk090_nmos2v #(.ps(19.2u), .m(1 * 2), .as(5.4p), .l(280.0n), .pd(9.6u),
 .ad(2.7p), .w(9u)) (*
integer library_binding = "gpdk090";
integer
passed_mfactor = "m";
 *)
NM11 ( UPp, s1, net99, VSS );
gpdk090_nmos2v #(.ps(19.2u), .m(1 * 2), .as(5.4p), .l(280.0n), .pd(9.6u),
 .ad(2.7p), .w(9u)) (*
integer library_binding = "gpdk090";
integer
passed_mfactor = "m";
 *)
NM16 ( VREF, net096, net80, VSS );

gpdk090_pmos2v #(.ps(3.2u), .m(1 * 1), .as(600f), .l(280.0n), .pd(3.2u),
 .ad(600f), .w(1u)) (*
integer library_binding = "gpdk090";
integer
passed_mfactor = "m";
 *)
PM16 ( IPLY_25u, SLEEPb, VDD, VDD );
gpdk090_pmos2v #(.ps(13.2u), .m(1 * 1), .as(3.6p), .l(280.0n), .pd(13.2u),
 .ad(3.6p), .w(6u)) (*
integer library_binding = "gpdk090";
integer
passed_mfactor = "m";
 *)
PM7 ( IPLY_25u, FB_IN, VDD, VDD );
gpdk090_pmos2v #(.ps(17.2u), .m(1 * 2), .as(4.8p), .l(1u), .pd(8.6u),
.ad(2.4p), .w(8u)) (*
integer library_binding = "gpdk090";
integer
passed_mfactor = "m";
 *)
PM6 ( net78, IPLY_25u, VDD, VDD );

gpdk090_pmoscap2v #(.m(1 * 10), .l(4.155u), .w(3.905u)) (*
integer
library_binding = "gpdk090";
integer passed_mfactor = "m";
 *)
C10 (
VDD, VREF, VDD, VDD );
gpdk090_pmoscap2v #(.m(1 * 60), .l(4.155u), .w(3.905u)) (*
integer
library_binding = "gpdk090";
integer passed_mfactor = "m";
 *)
C8 (
VDD, IPLY_25u, VDD, VDD );
gpdk090_pmoscap2v #(.m(1 * 10), .l(4.155u), .w(3.905u)) (*
integer
library_binding = "gpdk090";
integer passed_mfactor = "m";
 *)
C3 (
VDD, net117, VDD, VDD );

PLL_INV10X (*
integer library_binding = "ether";
 *)
I13 ( .VDD( VDD ),
.Y( s1b ), .VSS( VSS ), .A( net55 ) );
PLL_INV10X (*
integer library_binding = "ether";
 *)
I26 ( .VDD( VDD ),
.Y( s1 ), .VSS( VSS ), .A( s1b ) );
PLL_INV10X (*
integer library_binding = "ether";
 *)
I27 ( .VDD( VDD ),
.Y( net63 ), .VSS( VSS ), .A( s1 ) );

PLL_INV3X (*
integer library_binding = "ether";
 *)
I24 ( .VDD( VDD ),
.Y( SLEEPb ), .VSS( VSS ), .A( PD ) );
PLL_INV3X (*
integer library_binding = "ether";
 *)
I25 ( .VDD( VDD ),
.Y( SLEEP ), .VSS( VSS ), .A( SLEEPb ) );
PLL_INV3X (*
integer library_binding = "ether";
 *)
I8 ( .VDD( VDD ),
.Y( net55 ), .VSS( VSS ), .A( UP ) );

endmodule
