// Verilog-AMS netlist generated by the AMS netlister, version ICOA5.2.51.500.7.
// Cadence Design Systems, Inc.

`include "disciplines.vams"

module tenbt_rec_squelch_res_ladder ( gnd,sq00highp,sq00low10highn,
sq01highp,sq01low11highp,sq10lowp,sq11lowp,sq11lown,sq10lown,
sq01low11highn,sq00low10highp,sq01highn,sq00highn,sq_offn,sq_offp );

input   gnd;
output   sq00highp;
output   sq00low10highn;
output
 sq01highp;
output   sq01low11highp;
output   sq10lowp;
output
 sq11lowp;
output   sq11lown;
output   sq10lown;
output
 sq01low11highn;
output   sq00low10highp;
output   sq01highn;
output
 sq00highn;
output   sq_offn;
output   sq_offp;

gpdk090_resnsppoly #(.w(4u), .r(1.01943K), .l(10.185u)) (*
integer
library_binding = "gpdk090";
 *)
RDummy ( gnd, gnd, gnd );
gpdk090_resnsppoly #(.w(20u), .r(203.886), .l(10.185u)) (*
integer
library_binding = "gpdk090";
 *)
R12 ( sq00low10highn, sq01highn, gnd );
gpdk090_resnsppoly #(.w(20u), .r(203.886), .l(10.185u)) (*
integer
library_binding = "gpdk090";
 *)
R11 ( sq01low11highn, sq00low10highn,
gnd );
gpdk090_resnsppoly #(.w(2u), .r(30.5829K), .l(152.975u)) (*
integer
library_binding = "gpdk090";
 *)
R3 ( sq00highn, gnd, gnd );
gpdk090_resnsppoly #(.w(12u), .r(339.811), .l(10.185u)) (*
integer
library_binding = "gpdk090";
 *)
R0 ( sq_offp, sq_offn, gnd );
gpdk090_resnsppoly #(.w(4u), .r(1.01943K), .l(10.185u)) (*
integer
library_binding = "gpdk090";
 *)
R6 ( sq11lowp, sq_offp, gnd );
gpdk090_resnsppoly #(.w(4u), .r(1.01943K), .l(10.185u)) (*
integer
library_binding = "gpdk090";
 *)
R8 ( sq_offn, sq11lown, gnd );
gpdk090_resnsppoly #(.w(20u), .r(203.886), .l(10.185u)) (*
integer
library_binding = "gpdk090";
 *)
R13 ( sq01highn, sq00highn, gnd );
gpdk090_resnsppoly #(.w(20u), .r(203.886), .l(10.185u)) (*
integer
library_binding = "gpdk090";
 *)
R1 ( sq01highp, sq00low10highp, gnd );
gpdk090_resnsppoly #(.w(20u), .r(203.886), .l(10.185u)) (*
integer
library_binding = "gpdk090";
 *)
R5 ( sq01low11highp, sq10lowp, gnd );
gpdk090_resnsppoly #(.w(20u), .r(203.886), .l(10.185u)) (*
integer
library_binding = "gpdk090";
 *)
R2 ( sq00low10highp, sq01low11highp,
gnd );
gpdk090_resnsppoly #(.w(20u), .r(203.886), .l(10.185u)) (*
integer
library_binding = "gpdk090";
 *)
R14 ( sq00highp, sq01highp, gnd );
gpdk090_resnsppoly #(.w(20u), .r(203.886), .l(10.185u)) (*
integer
library_binding = "gpdk090";
 *)
R7 ( sq10lowp, sq11lowp, gnd );
gpdk090_resnsppoly #(.w(20u), .r(203.886), .l(10.185u)) (*
integer
library_binding = "gpdk090";
 *)
R9 ( sq11lown, sq10lown, gnd );
gpdk090_resnsppoly #(.w(20u), .r(203.886), .l(10.185u)) (*
integer
library_binding = "gpdk090";
 *)
R10 ( sq10lown, sq01low11highn, gnd );

endmodule
