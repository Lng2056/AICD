// Verilog-AMS netlist generated by the AMS netlister, version ICOA5.2.51.500.7.
// Cadence Design Systems, Inc.

`include "disciplines.vams"

module tenbt_rec_4_input_comp ( out_neg,out_pos,gnd,in_pos1,vbias,vdd,
in_pos2,siddq,in_neg1,in_neg2 );

output   out_neg;
output   out_pos;
input   gnd;
input   in_pos1;

input   vbias;
input   vdd;
input   in_pos2;
input   siddq;
input
 in_neg1;
input   in_neg2;

gpdk090_resnsppoly #(.w(2u), .r(13.9979K), .l(69.9829u)) (*
integer
library_binding = "gpdk090";
 *)
R1 ( vdd, out_pos, gnd );
gpdk090_resnsppoly #(.w(2u), .r(13.9979K), .l(69.9829u)) (*
integer
library_binding = "gpdk090";
 *)
R0 ( vdd, out_neg, gnd );

gpdk090_nmos2v #(.ps(1.01u), .m(2 * 1), .as(72.6f), .l(2u), .pd(1.01u),
 .ad(72.6f), .w(150n)) (*
integer library_binding = "gpdk090";

integer passed_mfactor = "m";
 *)
NM5 ( out_pos, in_neg1, net26, gnd );
gpdk090_nmos2v #(.ps(1.01u), .m(4 * 1), .as(72.6f), .l(2u), .pd(1.01u),
 .ad(72.6f), .w(150n)) (*
integer library_binding = "gpdk090";

integer passed_mfactor = "m";
 *)
NMDummy ( gnd, gnd, gnd, gnd );
gpdk090_nmos2v #(.ps(37.2u), .m(2 * 1), .as(10.8p), .l(2u), .pd(37.2u),
 .ad(10.8p), .w(18u)) (*
integer library_binding = "gpdk090";
integer
passed_mfactor = "m";
 *)
NMDummy1 ( gnd, vbias, gnd, gnd );
gpdk090_nmos2v #(.ps(1.01u), .m(2 * 1), .as(72.6f), .l(2u), .pd(1.01u),
 .ad(72.6f), .w(150n)) (*
integer library_binding = "gpdk090";

integer passed_mfactor = "m";
 *)
NM0 ( out_neg, in_pos2, net22, gnd );
gpdk090_nmos2v #(.ps(37.2u), .m(1 * 1), .as(10.8p), .l(2u), .pd(37.2u),
 .ad(10.8p), .w(18u)) (*
integer library_binding = "gpdk090";
integer
passed_mfactor = "m";
 *)
NM1 ( net22, vbias, gnd, gnd );
gpdk090_nmos2v #(.ps(1.01u), .m(2 * 1), .as(72.6f), .l(2u), .pd(1.01u),
 .ad(72.6f), .w(150n)) (*
integer library_binding = "gpdk090";

integer passed_mfactor = "m";
 *)
NM2 ( out_pos, in_neg2, net22, gnd );
gpdk090_nmos2v #(.ps(1.01u), .m(2 * 1), .as(72.6f), .l(2u), .pd(1.01u),
 .ad(72.6f), .w(150n)) (*
integer library_binding = "gpdk090";

integer passed_mfactor = "m";
 *)
NM3 ( out_neg, in_pos1, net26, gnd );
gpdk090_nmos2v #(.ps(37.2u), .m(1 * 1), .as(10.8p), .l(2u), .pd(37.2u),
 .ad(10.8p), .w(18u)) (*
integer library_binding = "gpdk090";
integer
passed_mfactor = "m";
 *)
NM4 ( net26, vbias, gnd, gnd );

gpdk090_pmos2v #(.ps(2.8u), .m(1 * 1), .as(463f), .l(280.0n), .pd(2.8u),
 .ad(463f), .w(515n)) (*
integer library_binding = "gpdk090";
integer
passed_mfactor = "m";
 *)
PM0 ( net22, net45, vdd, vdd );
gpdk090_pmos2v #(.ps(2.8u), .m(1 * 1), .as(463f), .l(280.0n), .pd(2.8u),
 .ad(463f), .w(515n)) (*
integer library_binding = "gpdk090";
integer
passed_mfactor = "m";
 *)
PM14 ( net26, net45, vdd, vdd );

gpdk090_nmoscap2v #(.m(1 * 1), .l(16.275u), .w(16.225u)) (*
integer
library_binding = "gpdk090";
integer passed_mfactor = "m";
 *)
C0 (
gnd, vdd, gnd, gnd );

inv_1X (*
integer library_binding = "ether";
 *)
I2 ( .vss( gnd ), .VDD(
vdd ), .in( siddq ), .out( net45 ) );

endmodule
