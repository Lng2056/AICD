// Verilog-AMS netlist generated by the AMS netlister, version ICOA5.2.51.500.7.
// Cadence Design Systems, Inc.

`include "disciplines.vams"

module trans_ld_100tx_opamp_pfet_casv ( S,D,G,B );

inout   S;
inout   D;
inout   G;
inout   B;

gpdk090_nmos2v #(.ps(17.2u), .m(1 * 1), .as(4.8p), .l(500n), .pd(17.2u),
 .ad(4.8p), .w(8u)) (*
integer library_binding = "gpdk090";
integer
passed_mfactor = "m";
 *)
NM16 ( net61, G, net53, S );
gpdk090_nmos2v #(.ps(49.2u), .m(1 * 2), .as(14.4p), .l(4u), .pd(24.6u),
 .ad(7.2p), .w(24u)) (*
integer library_binding = "gpdk090";
integer
passed_mfactor = "m";
 *)
NM13 ( net57, G, S, S );
gpdk090_nmos2v #(.ps(49.2u), .m(1 * 2), .as(14.4p), .l(4u), .pd(24.6u),
 .ad(7.2p), .w(24u)) (*
integer library_binding = "gpdk090";
integer
passed_mfactor = "m";
 *)
NM0 ( net53, G, net57, S );
gpdk090_nmos2v #(.ps(17.2u), .m(1 * 1), .as(4.8p), .l(500n), .pd(17.2u),
 .ad(4.8p), .w(8u)) (*
integer library_binding = "gpdk090";
integer
passed_mfactor = "m";
 *)
NM4 ( D, G, net61, S );

endmodule
