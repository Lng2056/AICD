// Verilog-AMS netlist generated by the AMS netlister, version ICOA5.2.51.500.7.
// Cadence Design Systems, Inc.

`include "disciplines.vams"

module PLL_250MHZ ( CLK_250MHZ_PH,SIDDQ,IPLY_25u,DISABLE,IEXT_100u,
CLK_25MHZ,CP_ITEST_25u,VDD,IEXT_25u,VSS );

output [10:0]  CLK_250MHZ_PH;
input   SIDDQ;
input   IPLY_25u;

input   DISABLE;
input   IEXT_100u;
input   CLK_25MHZ;
output
 CP_ITEST_25u;
input   VDD;
input   IEXT_25u;
input   VSS;

gpdk090_nmoscap2v #(.m(1 * 1), .l(12.865u), .w(12.82u)) (*
integer
library_binding = "gpdk090";
integer passed_mfactor = "m";
integer
elaboration_binding = "C0[1:158]";
 *)
C0_1 ( VSS, VDD, VSS, VSS ),
  C0_2 ( VSS, VDD, VSS, VSS ),
  C0_3 ( VSS, VDD, VSS, VSS ),
  C0_4 ( VSS, VDD, VSS, VSS ),
  C0_5 ( VSS, VDD, VSS, VSS ),
  C0_6 ( VSS, VDD, VSS, VSS ),
  C0_7 ( VSS, VDD, VSS, VSS ),
  C0_8 ( VSS, VDD, VSS, VSS ),
  C0_9 ( VSS, VDD, VSS, VSS ),
  C0_10 ( VSS, VDD, VSS, VSS ),
  C0_11 ( VSS, VDD, VSS, VSS ),
  C0_12 ( VSS, VDD, VSS, VSS ),
  C0_13 ( VSS, VDD, VSS, VSS ),
  C0_14 ( VSS, VDD, VSS, VSS ),
  C0_15 ( VSS, VDD, VSS, VSS ),
  C0_16 ( VSS, VDD, VSS, VSS ),
  C0_17 ( VSS, VDD, VSS, VSS ),
  C0_18 ( VSS, VDD, VSS, VSS ),
  C0_19 ( VSS, VDD, VSS, VSS ),
  C0_20 ( VSS, VDD, VSS, VSS ),
  C0_21 ( VSS, VDD, VSS, VSS ),
  C0_22 ( VSS, VDD, VSS, VSS ),
  C0_23 ( VSS, VDD, VSS, VSS ),
  C0_24 ( VSS, VDD, VSS, VSS ),
  C0_25 ( VSS, VDD, VSS, VSS ),
  C0_26 ( VSS, VDD, VSS, VSS ),
  C0_27 ( VSS, VDD, VSS, VSS ),
  C0_28 ( VSS, VDD, VSS, VSS ),
  C0_29 ( VSS, VDD, VSS, VSS ),
  C0_30 ( VSS, VDD, VSS, VSS ),
  C0_31 ( VSS, VDD, VSS, VSS ),
  C0_32 ( VSS, VDD, VSS, VSS ),
  C0_33 ( VSS, VDD, VSS, VSS ),
  C0_34 ( VSS, VDD, VSS, VSS ),
  C0_35 ( VSS, VDD, VSS, VSS ),
  C0_36 ( VSS, VDD, VSS, VSS ),
  C0_37 ( VSS, VDD, VSS, VSS ),
  C0_38 ( VSS, VDD, VSS, VSS ),
  C0_39 ( VSS, VDD, VSS, VSS ),
  C0_40 ( VSS, VDD, VSS, VSS ),
  C0_41 ( VSS, VDD, VSS, VSS ),
  C0_42 ( VSS, VDD, VSS, VSS ),
  C0_43 ( VSS, VDD, VSS, VSS ),
  C0_44 ( VSS, VDD, VSS, VSS ),
  C0_45 ( VSS, VDD, VSS, VSS ),
  C0_46 ( VSS, VDD, VSS, VSS ),
  C0_47 ( VSS, VDD, VSS, VSS ),
  C0_48 ( VSS, VDD, VSS, VSS ),
  C0_49 ( VSS, VDD, VSS, VSS ),
  C0_50 ( VSS, VDD, VSS, VSS ),
  C0_51 ( VSS, VDD, VSS, VSS ),
  C0_52 ( VSS, VDD, VSS, VSS ),
  C0_53 ( VSS, VDD, VSS, VSS ),
  C0_54 ( VSS, VDD, VSS, VSS ),
  C0_55 ( VSS, VDD, VSS, VSS ),
  C0_56 ( VSS, VDD, VSS, VSS ),
  C0_57 ( VSS, VDD, VSS, VSS ),
  C0_58 ( VSS, VDD, VSS, VSS ),
  C0_59 ( VSS, VDD, VSS, VSS ),
  C0_60 ( VSS, VDD, VSS, VSS ),
  C0_61 ( VSS, VDD, VSS, VSS ),
  C0_62 ( VSS, VDD, VSS, VSS ),
  C0_63 ( VSS, VDD, VSS, VSS ),
  C0_64 ( VSS, VDD, VSS, VSS ),
  C0_65 ( VSS, VDD, VSS, VSS ),
  C0_66 ( VSS, VDD, VSS, VSS ),
  C0_67 ( VSS, VDD, VSS, VSS ),
  C0_68 ( VSS, VDD, VSS, VSS ),
  C0_69 ( VSS, VDD, VSS, VSS ),
  C0_70 ( VSS, VDD, VSS, VSS ),
  C0_71 ( VSS, VDD, VSS, VSS ),
  C0_72 ( VSS, VDD, VSS, VSS ),
  C0_73 ( VSS, VDD, VSS, VSS ),
  C0_74 ( VSS, VDD, VSS, VSS ),
  C0_75 ( VSS, VDD, VSS, VSS ),
  C0_76 ( VSS, VDD, VSS, VSS ),
  C0_77 ( VSS, VDD, VSS, VSS ),
  C0_78 ( VSS, VDD, VSS, VSS ),
  C0_79 ( VSS, VDD, VSS, VSS ),
  C0_80 ( VSS, VDD, VSS, VSS ),
  C0_81 ( VSS, VDD, VSS, VSS ),
  C0_82 ( VSS, VDD, VSS, VSS ),
  C0_83 ( VSS, VDD, VSS, VSS ),
  C0_84 ( VSS, VDD, VSS, VSS ),
  C0_85 ( VSS, VDD, VSS, VSS ),
  C0_86 ( VSS, VDD, VSS, VSS ),
  C0_87 ( VSS, VDD, VSS, VSS ),
  C0_88 ( VSS, VDD, VSS, VSS ),
  C0_89 ( VSS, VDD, VSS, VSS ),
  C0_90 ( VSS, VDD, VSS, VSS ),
  C0_91 ( VSS, VDD, VSS, VSS ),
  C0_92 ( VSS, VDD, VSS, VSS ),
  C0_93 ( VSS, VDD, VSS, VSS ),
  C0_94 ( VSS, VDD, VSS, VSS ),
  C0_95 ( VSS, VDD, VSS, VSS ),
  C0_96 ( VSS, VDD, VSS, VSS ),
  C0_97 ( VSS, VDD, VSS, VSS ),
  C0_98 ( VSS, VDD, VSS, VSS ),
  C0_99 ( VSS, VDD, VSS, VSS ),
  C0_100 ( VSS, VDD, VSS, VSS ),
  C0_101 ( VSS, VDD, VSS, VSS ),
  C0_102 ( VSS, VDD, VSS, VSS ),
  C0_103 ( VSS, VDD, VSS, VSS ),
  C0_104 ( VSS, VDD, VSS, VSS ),
  C0_105 ( VSS, VDD, VSS, VSS ),
  C0_106 ( VSS, VDD, VSS, VSS ),
  C0_107 ( VSS, VDD, VSS, VSS ),
  C0_108 ( VSS, VDD, VSS, VSS ),
  C0_109 ( VSS, VDD, VSS, VSS ),
  C0_110 ( VSS, VDD, VSS, VSS ),
  C0_111 ( VSS, VDD, VSS, VSS ),
  C0_112 ( VSS, VDD, VSS, VSS ),
  C0_113 ( VSS, VDD, VSS, VSS ),
  C0_114 ( VSS, VDD, VSS, VSS ),
  C0_115 ( VSS, VDD, VSS, VSS ),
  C0_116 ( VSS, VDD, VSS, VSS ),
  C0_117 ( VSS, VDD, VSS, VSS ),
  C0_118 ( VSS, VDD, VSS, VSS ),
  C0_119 ( VSS, VDD, VSS, VSS ),
  C0_120 ( VSS, VDD, VSS, VSS ),
  C0_121 ( VSS, VDD, VSS, VSS ),
  C0_122 ( VSS, VDD, VSS, VSS ),
  C0_123 ( VSS, VDD, VSS, VSS ),
  C0_124 ( VSS, VDD, VSS, VSS ),
  C0_125 ( VSS, VDD, VSS, VSS ),
  C0_126 ( VSS, VDD, VSS, VSS ),
  C0_127 ( VSS, VDD, VSS, VSS ),
  C0_128 ( VSS, VDD, VSS, VSS ),
  C0_129 ( VSS, VDD, VSS, VSS ),
  C0_130 ( VSS, VDD, VSS, VSS ),
  C0_131 ( VSS, VDD, VSS, VSS ),
  C0_132 ( VSS, VDD, VSS, VSS ),
  C0_133 ( VSS, VDD, VSS, VSS ),
  C0_134 ( VSS, VDD, VSS, VSS ),
  C0_135 ( VSS, VDD, VSS, VSS ),
  C0_136 ( VSS, VDD, VSS, VSS ),
  C0_137 ( VSS, VDD, VSS, VSS ),
  C0_138 ( VSS, VDD, VSS, VSS ),
  C0_139 ( VSS, VDD, VSS, VSS ),
  C0_140 ( VSS, VDD, VSS, VSS ),
  C0_141 ( VSS, VDD, VSS, VSS ),
  C0_142 ( VSS, VDD, VSS, VSS ),
  C0_143 ( VSS, VDD, VSS, VSS ),
  C0_144 ( VSS, VDD, VSS, VSS ),
  C0_145 ( VSS, VDD, VSS, VSS ),
  C0_146 ( VSS, VDD, VSS, VSS ),
  C0_147 ( VSS, VDD, VSS, VSS ),
  C0_148 ( VSS, VDD, VSS, VSS ),
  C0_149 ( VSS, VDD, VSS, VSS ),
  C0_150 ( VSS, VDD, VSS, VSS ),
  C0_151 ( VSS, VDD, VSS, VSS ),
  C0_152 ( VSS, VDD, VSS, VSS ),
  C0_153 ( VSS, VDD, VSS, VSS ),
  C0_154 ( VSS, VDD, VSS, VSS ),
  C0_155 ( VSS, VDD, VSS, VSS ),
  C0_156 ( VSS, VDD, VSS, VSS ),
  C0_157 ( VSS, VDD, VSS, VSS ),
  C0_158 ( VSS, VDD, VSS, VSS );

clkbuf_4x_hv (*
integer library_binding = "ether";
integer cds_net_set
[0:1] = { "DVSS","DVDD" };
integer DVSS = "VSS";
integer DVDD
 = "VDD";
 *)
I7 ( .Y( net29 ), .A( CLK_25MHZ ) );

or2_4x_hv (*
integer library_binding = "ether";
integer cds_net_set
[0:1] = { "DVDD","DVSS" };
integer DVDD = "VDD";
integer DVSS
 = "VSS";
 *)
I84 ( .Y( PD ), .B( SIDDQ ), .A( DISABLE ) );

PLL_250MHZ_MDIV (*
integer library_binding = "ether";
integer
cds_net_set[0:1] = { "DVDD","DVSS" };
integer DVDD = "VDD";
integer
DVSS = "VSS";
 *)
I23 ( .CLKFB( FBCLK ), .CLKVCO( CLK_250MHZ_PH[0] ) );

PLL_ARST_DIG (*
integer library_binding = "ether";
integer cds_net_set
[0:1] = { "DVSS","DVDD" };
integer DVSS = "VSS";
integer DVDD
 = "VDD";
 *)
I32 ( .DUMP( DUMP ), .COMP( CMPOUT ), .VDD( VDD ), .REFCLK(
CLK_25MHZ ), .PD( PD ), .VSS( VSS ) );

PLL_250MHZ_LF (*
integer library_binding = "ether";
 *)
I18 ( .DUMP(
DUMP ), .TAP( TAP ), .LF( VCONT ), .VSS( VSS ) );

PLL_ARST (*
integer library_binding = "ether";
 *)
I34 ( .COMP( CMPOUT ),
.LFTAP( TAP ), .VDD( VDD ), .PD( PD ), .VSS( VSS ), .Ibias( IEXT_25u ) );

PLL_VCO_250MHZ (*
integer library_binding = "ether";
 *)
I22 ( .VCO_CLK_PH(
CLK_250MHZ_PH[10:0] ), .IEXT_100u( IEXT_100u ), .VDD( VDD ), .PD( PD ),
.VSS( VSS ), .Vcontrol( VCONT ) );

PLL_PFD (*
integer library_binding = "ether";
integer cds_net_set[0:1]
 = { "DVSS","DVDD" };
integer DVSS = "VSS";
integer DVDD = "VDD";
 *)

I11 ( .VDD( VDD ), .REFCLK( net29 ), .UP( UP ), .PD( PD ), .VSS( VSS ),
.DN( DN ), .FBCLK( FBCLK ) );

PLL_CP (*
integer library_binding = "ether";
 *)
I12 ( .IPLY_25u(
IPLY_25u ), .CP_ITEST_25u( CP_ITEST_25u ), .VDD( VDD ), .UP( UP ), .OUT(
VCONT ), .PD( PD ), .DN( DN ), .VSS( VSS ) );

endmodule
