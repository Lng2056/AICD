// Verilog-AMS netlist generated by the AMS netlister, version ICOA5.2.51.500.7.
// Cadence Design Systems, Inc.

`include "disciplines.vams"

module blw_dac_in_res_v2 ( INP,OUTP,Vcm,OUTM,AGND,INM );

input   INP;
output   OUTP;
output   Vcm;
output   OUTM;
input
 AGND;
input   INM;

gpdk090_resnsppoly #(.w(2u), .r(3.19968K), .l(15.985u)) (*
integer
library_binding = "gpdk090";
 *)
R5 ( AGND, AGND, AGND );
gpdk090_resnsppoly #(.w(2u), .r(3.19968K), .l(15.985u)) (*
integer
library_binding = "gpdk090";
 *)
R4 ( OUTM, Vcm, AGND );
gpdk090_resnsppoly #(.w(2u), .r(3.19968K), .l(15.985u)) (*
integer
library_binding = "gpdk090";
 *)
R3 ( Vcm, OUTP, AGND );
gpdk090_resnsppoly #(.w(2u), .r(3.19968K), .l(15.985u)) (*
integer
library_binding = "gpdk090";
 *)
R2 ( OUTM, INM, AGND );
gpdk090_resnsppoly #(.w(2u), .r(3.19968K), .l(15.985u)) (*
integer
library_binding = "gpdk090";
 *)
R1 ( OUTP, INP, AGND );

endmodule
