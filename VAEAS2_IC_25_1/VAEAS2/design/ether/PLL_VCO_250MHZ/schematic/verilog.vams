// Verilog-AMS netlist generated by the AMS netlister, version ICOA5.2.51.500.7.
// Cadence Design Systems, Inc.

`include "disciplines.vams"

module PLL_VCO_250MHZ ( VCO_CLK_PH,IEXT_100u,VDD,PD,VSS,Vcontrol );

output [0:10]  VCO_CLK_PH;
input   IEXT_100u;
input   VDD;
input
 PD;
input   VSS;
input   Vcontrol;

parameter start_time=0;
parameter VCTHRESH=0.3;
parameter _tvco_des_var_tmp=0;
parameter tvco=_tvco_des_var_tmp;
parameter KVCO=340;
parameter fvco=2.5E+09;
parameter _treg_des_var_tmp=0;
parameter treg=_treg_des_var_tmp;
parameter freg=4.16667E+08;
parameter ttol=0;

defparam _tvco_des_var_tmp=( 1.000000000000000 / cds_globals.fvco );
defparam _treg_des_var_tmp=( 1.000000000000000 / cds_globals.freg );

capacitor #(.c(30f)) (*
integer library_binding = "analogLib";
 *)
C16
 ( INV_8_N, VSS );
capacitor #(.c(30f)) (*
integer library_binding = "analogLib";
 *)
C20
 ( INV_2_N, VSS );
capacitor #(.c(30f)) (*
integer library_binding = "analogLib";
 *)
C2
 ( INV_4_P, VSS );
capacitor #(.c(30f)) (*
integer library_binding = "analogLib";
 *)
C3
 ( INV_3_P, VSS );
capacitor #(.c(30f)) (*
integer library_binding = "analogLib";
 *)
C6
 ( INV_5_P, VSS );
capacitor #(.c(30f)) (*
integer library_binding = "analogLib";
 *)
C13
 ( INV_10_N, VSS );
capacitor #(.c(30f)) (*
integer library_binding = "analogLib";
 *)
C12
 ( INV_9_N, VSS );
capacitor #(.c(30f)) (*
integer library_binding = "analogLib";
 *)
C14
 ( INV_6_N, VSS );
capacitor #(.c(30f)) (*
integer library_binding = "analogLib";
 *)
C10
 ( INV_11_P, VSS );
capacitor #(.c(30f)) (*
integer library_binding = "analogLib";
 *)
C18
 ( INV_3_N, VSS );
capacitor #(.c(30f)) (*
integer library_binding = "analogLib";
 *)
C4
 ( INV_7_P, VSS );
capacitor #(.c(30f)) (*
integer library_binding = "analogLib";
 *)
C21
 ( INV_1_N, VSS );
capacitor #(.c(30f)) (*
integer library_binding = "analogLib";
 *)
C5
 ( INV_8_P, VSS );
capacitor #(.c(30f)) (*
integer library_binding = "analogLib";
 *)
C9
 ( INV_9_P, VSS );
capacitor #(.c(30f)) (*
integer library_binding = "analogLib";
 *)
C17
 ( INV_7_N, VSS );
capacitor #(.c(30f)) (*
integer library_binding = "analogLib";
 *)
C7
 ( INV_6_P, VSS );
capacitor #(.c(30f)) (*
integer library_binding = "analogLib";
 *)
C15
 ( INV_5_N, VSS );
capacitor #(.c(30f)) (*
integer library_binding = "analogLib";
 *)
C8
 ( INV_10_P, VSS );
capacitor #(.c(30f)) (*
integer library_binding = "analogLib";
 *)
C19
 ( INV_4_N, VSS );
capacitor #(.c(30f)) (*
integer library_binding = "analogLib";
 *)
C11
 ( INV_11_N, VSS );
capacitor #(.c(30f)) (*
integer library_binding = "analogLib";
 *)
C0
 ( INV_1_P, VSS );
capacitor #(.c(60f)) (*
integer library_binding = "analogLib";

integer elaboration_binding = "C22[0:10]";
 *)
C22_0 ( VCO_CLK_PH[0],
VSS ),
  C22_1 ( VCO_CLK_PH[1], VSS ),
  C22_2 ( VCO_CLK_PH[2], VSS ),
  C22_3 ( VCO_CLK_PH[3], VSS ),
  C22_4 ( VCO_CLK_PH[4], VSS ),
  C22_5 ( VCO_CLK_PH[5], VSS ),
  C22_6 ( VCO_CLK_PH[6], VSS ),
  C22_7 ( VCO_CLK_PH[7], VSS ),
  C22_8 ( VCO_CLK_PH[8], VSS ),
  C22_9 ( VCO_CLK_PH[9], VSS ),
  C22_10 ( VCO_CLK_PH[10], VSS );
capacitor #(.c(30f)) (*
integer library_binding = "analogLib";
 *)
C1
 ( INV_2_P, VSS );

PLL_VCO_INV250 (*
integer library_binding = "ether";
 *)
INVC3 ( .VDD(
Vring ), .Y( INV_3_N ), .VSS( VSS ), .A( INV_3_P ) );
PLL_VCO_INV250 (*
integer library_binding = "ether";
 *)
INVC9 ( .VDD(
Vring ), .Y( INV_9_N ), .VSS( VSS ), .A( INV_9_P ) );
PLL_VCO_INV250 (*
integer library_binding = "ether";
 *)
INVC1 ( .VDD(
Vring ), .Y( INV_1_N ), .VSS( VSS ), .A( INV_1_P ) );
PLL_VCO_INV250 (*
integer library_binding = "ether";
 *)
INVC5 ( .VDD(
Vring ), .Y( INV_5_N ), .VSS( VSS ), .A( INV_5_P ) );
PLL_VCO_INV250 (*
integer library_binding = "ether";
 *)
INVC6 ( .VDD(
Vring ), .Y( INV_6_P ), .VSS( VSS ), .A( INV_6_N ) );
PLL_VCO_INV250 (*
integer library_binding = "ether";
 *)
INVC7 ( .VDD(
Vring ), .Y( INV_7_N ), .VSS( VSS ), .A( INV_7_P ) );
PLL_VCO_INV250 (*
integer library_binding = "ether";
 *)
INVC8 ( .VDD(
Vring ), .Y( INV_8_P ), .VSS( VSS ), .A( INV_8_N ) );
PLL_VCO_INV250 (*
integer library_binding = "ether";
 *)
INVC10 ( .VDD(
Vring ), .Y( INV_10_P ), .VSS( VSS ), .A( INV_10_N ) );
PLL_VCO_INV250 (*
integer library_binding = "ether";
 *)
INVC2 ( .VDD(
Vring ), .Y( INV_2_P ), .VSS( VSS ), .A( INV_2_N ) );
PLL_VCO_INV250 (*
integer library_binding = "ether";
 *)
INVC4 ( .VDD(
Vring ), .Y( INV_4_P ), .VSS( VSS ), .A( INV_4_N ) );

PLL_VCO_250MHZ_INV (*
integer library_binding = "ether";
 *)
INVP10 (
.VDD( Vring ), .Y( INV_10_P ), .VSS( VSS ), .A( INV_9_P ) );
PLL_VCO_250MHZ_INV (*
integer library_binding = "ether";
 *)
INVN11 (
.VDD( Vring ), .Y( INV_11_N ), .VSS( VSS ), .A( INV_10_N ) );
PLL_VCO_250MHZ_INV (*
integer library_binding = "ether";
 *)
INVP11 (
.VDD( Vring ), .Y( INV_11_P ), .VSS( VSS ), .A( INV_10_P ) );
PLL_VCO_250MHZ_INV (*
integer library_binding = "ether";
 *)
INVP6 ( .VDD(
Vring ), .Y( INV_6_P ), .VSS( VSS ), .A( INV_5_P ) );
PLL_VCO_250MHZ_INV (*
integer library_binding = "ether";
 *)
INVN6 ( .VDD(
Vring ), .Y( INV_6_N ), .VSS( VSS ), .A( INV_5_N ) );
PLL_VCO_250MHZ_INV (*
integer library_binding = "ether";
 *)
INVN1 ( .VDD(
Vring ), .Y( INV_1_N ), .VSS( VSS ), .A( INV_11_N ) );
PLL_VCO_250MHZ_INV (*
integer library_binding = "ether";
 *)
INVN2 ( .VDD(
Vring ), .Y( INV_2_N ), .VSS( VSS ), .A( INV_1_N ) );
PLL_VCO_250MHZ_INV (*
integer library_binding = "ether";
 *)
INVN3 ( .VDD(
Vring ), .Y( INV_3_N ), .VSS( VSS ), .A( INV_2_N ) );
PLL_VCO_250MHZ_INV (*
integer library_binding = "ether";
 *)
INVN4 ( .VDD(
Vring ), .Y( INV_4_N ), .VSS( VSS ), .A( INV_3_N ) );
PLL_VCO_250MHZ_INV (*
integer library_binding = "ether";
 *)
INVN5 ( .VDD(
Vring ), .Y( INV_5_N ), .VSS( VSS ), .A( INV_4_N ) );
PLL_VCO_250MHZ_INV (*
integer library_binding = "ether";
 *)
INVP5 ( .VDD(
Vring ), .Y( INV_5_P ), .VSS( VSS ), .A( INV_4_P ) );
PLL_VCO_250MHZ_INV (*
integer library_binding = "ether";
 *)
INVP4 ( .VDD(
Vring ), .Y( INV_4_P ), .VSS( VSS ), .A( INV_3_P ) );
PLL_VCO_250MHZ_INV (*
integer library_binding = "ether";
 *)
INVP3 ( .VDD(
Vring ), .Y( INV_3_P ), .VSS( VSS ), .A( INV_2_P ) );
PLL_VCO_250MHZ_INV (*
integer library_binding = "ether";
 *)
INVP2 ( .VDD(
Vring ), .Y( INV_2_P ), .VSS( VSS ), .A( INV_1_P ) );
PLL_VCO_250MHZ_INV (*
integer library_binding = "ether";
 *)
INVP1 ( .VDD(
Vring ), .Y( INV_1_P ), .VSS( VSS ), .A( INV_11_P ) );
PLL_VCO_250MHZ_INV (*
integer library_binding = "ether";
 *)
INVN8 ( .VDD(
Vring ), .Y( INV_8_N ), .VSS( VSS ), .A( INV_7_N ) );
PLL_VCO_250MHZ_INV (*
integer library_binding = "ether";
 *)
INVP7 ( .VDD(
Vring ), .Y( INV_7_P ), .VSS( VSS ), .A( INV_6_P ) );
PLL_VCO_250MHZ_INV (*
integer library_binding = "ether";
 *)
INVP8 ( .VDD(
Vring ), .Y( INV_8_P ), .VSS( VSS ), .A( INV_7_P ) );
PLL_VCO_250MHZ_INV (*
integer library_binding = "ether";
 *)
INVN7 ( .VDD(
Vring ), .Y( INV_7_N ), .VSS( VSS ), .A( INV_6_N ) );
PLL_VCO_250MHZ_INV (*
integer library_binding = "ether";
 *)
INVP9 ( .VDD(
Vring ), .Y( INV_9_P ), .VSS( VSS ), .A( INV_8_P ) );
PLL_VCO_250MHZ_INV (*
integer library_binding = "ether";
 *)
INVN9 ( .VDD(
Vring ), .Y( INV_9_N ), .VSS( VSS ), .A( INV_8_N ) );
PLL_VCO_250MHZ_INV (*
integer library_binding = "ether";
 *)
INVN10 (
.VDD( Vring ), .Y( INV_10_N ), .VSS( VSS ), .A( INV_9_N ) );

PLL_VCO_CMOSDVR (*
integer library_binding = "ether";
 *)
I57 ( .INn(
INV_3_P ), .VDD( VDD ), .INp( INV_3_N ), .PD( PD ), .OUT(
VCO_CLK_PH[1] ), .VSS( VSS ) );
PLL_VCO_CMOSDVR (*
integer library_binding = "ether";
 *)
I61 ( .INn(
INV_10_P ), .VDD( VDD ), .INp( INV_10_N ), .PD( PD ), .OUT(
VCO_CLK_PH[10] ), .VSS( VSS ) );
PLL_VCO_CMOSDVR (*
integer library_binding = "ether";
 *)
I64 ( .INn(
INV_4_P ), .VDD( VDD ), .INp( INV_4_N ), .PD( PD ), .OUT(
VCO_CLK_PH[7] ), .VSS( VSS ) );
PLL_VCO_CMOSDVR (*
integer library_binding = "ether";
 *)
I59 ( .INn(
INV_5_P ), .VDD( VDD ), .INp( INV_5_N ), .PD( PD ), .OUT(
VCO_CLK_PH[2] ), .VSS( VSS ) );
PLL_VCO_CMOSDVR (*
integer library_binding = "ether";
 *)
I63 ( .INn(
INV_8_P ), .VDD( VDD ), .INp( INV_8_N ), .PD( PD ), .OUT(
VCO_CLK_PH[9] ), .VSS( VSS ) );
PLL_VCO_CMOSDVR (*
integer library_binding = "ether";
 *)
I58 ( .INn(
INV_7_P ), .VDD( VDD ), .INp( INV_7_N ), .PD( PD ), .OUT(
VCO_CLK_PH[3] ), .VSS( VSS ) );
PLL_VCO_CMOSDVR (*
integer library_binding = "ether";
 *)
I65 ( .INn(
INV_2_P ), .VDD( VDD ), .INp( INV_2_N ), .PD( PD ), .OUT(
VCO_CLK_PH[6] ), .VSS( VSS ) );
PLL_VCO_CMOSDVR (*
integer library_binding = "ether";
 *)
I60 ( .INn(
INV_6_P ), .VDD( VDD ), .INp( INV_6_N ), .PD( PD ), .OUT(
VCO_CLK_PH[8] ), .VSS( VSS ) );
PLL_VCO_CMOSDVR (*
integer library_binding = "ether";
 *)
I66 ( .INn(
INV_1_P ), .VDD( VDD ), .INp( INV_1_N ), .PD( PD ), .OUT(
VCO_CLK_PH[0] ), .VSS( VSS ) );
PLL_VCO_CMOSDVR (*
integer library_binding = "ether";
 *)
I67 ( .INn(
INV_9_P ), .VDD( VDD ), .INp( INV_9_N ), .PD( PD ), .OUT(
VCO_CLK_PH[4] ), .VSS( VSS ) );
PLL_VCO_CMOSDVR (*
integer library_binding = "ether";
 *)
I46 ( .INn(
INV_11_P ), .VDD( VDD ), .INp( INV_11_N ), .PD( PD ), .OUT(
VCO_CLK_PH[5] ), .VSS( VSS ) );

PLL_VCO_REG (*
integer library_binding = "ether";
 *)
I62 ( .IEXT_100u(
IEXT_100u ), .VFB( Vring ), .VDD( VDD ), .PD( PD ), .VSS( VSS ), .Vcontrol(
Vcontrol ), .VRING( Vring ) );

endmodule
