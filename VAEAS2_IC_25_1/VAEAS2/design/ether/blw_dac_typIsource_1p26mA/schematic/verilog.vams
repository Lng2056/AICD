// Verilog-AMS netlist generated by the AMS netlister, version ICOA5.2.51.500.7.
// Cadence Design Systems, Inc.

`include "disciplines.vams"

module blw_dac_typIsource_1p26mA ( vbiasp_output,SIDDQb,ibiaspc_40u,
AVDD_2p5V,ibiasp_40u,Icm_200uA,Isource1_tt1p26mA,Isource2_tt1p26mA,
vbiaspc_output );

output   vbiasp_output;
input   SIDDQb;
input   ibiaspc_40u;
input
 AVDD_2p5V;
input   ibiasp_40u;
output   Icm_200uA;
output
 Isource1_tt1p26mA;
output   Isource2_tt1p26mA;
output
 vbiaspc_output;

gpdk090_resm3 #(.w(2u), .r(240m), .l(8u)) (*
integer library_binding
 = "gpdk090";
 *)
R1 ( vbiasp_output, ibiasp_40u );
gpdk090_resm3 #(.w(2u), .r(240m), .l(8u)) (*
integer library_binding
 = "gpdk090";
 *)
R0 ( vbiaspc_output, ibiaspc_40u );

gpdk090_pmos2v #(.ps(13.0065u), .m(2 * 31), .as(3.71613p), .l(300n), .pd(13.0065u),
 .ad(3.71613p), .w(12u)) (*
integer library_binding = "gpdk090";

integer passed_mfactor = "m";
 *)
PM6 ( Isource1_tt1p26mA,
vbiaspc_output, net113, AVDD_2p5V );
gpdk090_pmos2v #(.ps(13.0065u), .m(2 * 31), .as(3.71613p), .l(500n), .pd(13.0065u),
 .ad(3.71613p), .w(12u)) (*
integer library_binding = "gpdk090";

integer passed_mfactor = "m";
 *)
PM9 ( net113, vbiasp_output,
AVDD_2p5V, AVDD_2p5V );
gpdk090_pmos2v #(.ps(13.0065u), .m(2 * 31), .as(3.71613p), .l(500n), .pd(13.0065u),
 .ad(3.71613p), .w(12u)) (*
integer library_binding = "gpdk090";

integer passed_mfactor = "m";
 *)
PM0 ( net103, vbiasp_output,
AVDD_2p5V, AVDD_2p5V );
gpdk090_pmos2v #(.ps(25.2u), .m(1 * 1), .as(7.2p), .l(300n), .pd(25.2u),
 .ad(7.2p), .w(12u)) (*
integer library_binding = "gpdk090";
integer
passed_mfactor = "m";
 *)
PM1 ( Isource2_tt1p26mA, vbiaspc_output,
net103, AVDD_2p5V );
gpdk090_pmos2v #(.ps(13.0065u), .m(2 * 31), .as(3.71613p), .l(300n), .pd(13.0065u),
 .ad(3.71613p), .w(12u)) (*
integer library_binding = "gpdk090";

integer passed_mfactor = "m";
 *)
PM2 ( Isource2_tt1p26mA,
vbiaspc_output, net103, AVDD_2p5V );
gpdk090_pmos2v #(.ps(25.2u), .m(1 * 1), .as(7.2p), .l(500n), .pd(25.2u),
 .ad(7.2p), .w(12u)) (*
integer library_binding = "gpdk090";
integer
passed_mfactor = "m";
 *)
PM12 ( net103, vbiasp_output, AVDD_2p5V,
AVDD_2p5V );
gpdk090_pmos2v #(.ps(25.2u), .m(1 * 1), .as(7.2p), .l(500n), .pd(25.2u),
 .ad(7.2p), .w(12u)) (*
integer library_binding = "gpdk090";
integer
passed_mfactor = "m";
 *)
PM3 ( net113, AVDD_2p5V, AVDD_2p5V,
AVDD_2p5V );
gpdk090_pmos2v #(.ps(25.2u), .m(3 * 2), .as(7.2p), .l(500n), .pd(12.6u),
 .ad(3.6p), .w(12u)) (*
integer library_binding = "gpdk090";
integer
passed_mfactor = "m";
 *)
PM10 ( AVDD_2p5V, vbiasp_output, AVDD_2p5V,
AVDD_2p5V );
gpdk090_pmos2v #(.ps(25.2u), .m(1 * 1), .as(7.2p), .l(500n), .pd(25.2u),
 .ad(7.2p), .w(12u)) (*
integer library_binding = "gpdk090";
integer
passed_mfactor = "m";
 *)
PM8 ( net103, AVDD_2p5V, AVDD_2p5V,
AVDD_2p5V );
gpdk090_pmos2v #(.ps(13.2u), .m(1 * 1), .as(3.6p), .l(300n), .pd(13.2u),
 .ad(3.6p), .w(6u)) (*
integer library_binding = "gpdk090";
integer
passed_mfactor = "m";
 *)
PM18 ( vbiaspc_output, vbiaspc_output,
net123, AVDD_2p5V );
gpdk090_pmos2v #(.ps(3.2u), .m(1 * 1), .as(600f), .l(300n), .pd(3.2u),
 .ad(600f), .w(1u)) (*
integer library_binding = "gpdk090";
integer
passed_mfactor = "m";
 *)
PM4 ( vbiasp_output, SIDDQb, AVDD_2p5V,
AVDD_2p5V );
gpdk090_pmos2v #(.ps(3.2u), .m(1 * 1), .as(600f), .l(300n), .pd(3.2u),
 .ad(600f), .w(1u)) (*
integer library_binding = "gpdk090";
integer
passed_mfactor = "m";
 *)
PM45 ( vbiaspc_output, SIDDQb, AVDD_2p5V,
AVDD_2p5V );
gpdk090_pmos2v #(.ps(25.2u), .m(1 * 2), .as(7.2p), .l(300n), .pd(12.6u),
 .ad(3.6p), .w(12u)) (*
integer library_binding = "gpdk090";
integer
passed_mfactor = "m";
 *)
PM47 ( vbiasp_output, vbiaspc_output, net135,
AVDD_2p5V );
gpdk090_pmos2v #(.ps(25.2u), .m(1 * 2), .as(7.2p), .l(500n), .pd(12.6u),
 .ad(3.6p), .w(12u)) (*
integer library_binding = "gpdk090";
integer
passed_mfactor = "m";
 *)
PM50 ( net135, vbiasp_output, AVDD_2p5V,
AVDD_2p5V );
gpdk090_pmos2v #(.ps(13.2u), .m(1 * 1), .as(3.6p), .l(500n), .pd(13.2u),
 .ad(3.6p), .w(6u)) (*
integer library_binding = "gpdk090";
integer
passed_mfactor = "m";
 *)
PM17 ( net123, vbiaspc_output, AVDD_2p5V,
AVDD_2p5V );
gpdk090_pmos2v #(.ps(25.2u), .m(5 * 2), .as(7.2p), .l(300n), .pd(12.6u),
 .ad(3.6p), .w(12u)) (*
integer library_binding = "gpdk090";
integer
passed_mfactor = "m";
 *)
PM41 ( Icm_200uA, vbiaspc_output, net147,
AVDD_2p5V );
gpdk090_pmos2v #(.ps(25.2u), .m(5 * 2), .as(7.2p), .l(500n), .pd(12.6u),
 .ad(3.6p), .w(12u)) (*
integer library_binding = "gpdk090";
integer
passed_mfactor = "m";
 *)
PM40 ( net147, vbiasp_output, AVDD_2p5V,
AVDD_2p5V );
gpdk090_pmos2v #(.ps(25.2u), .m(1 * 1), .as(7.2p), .l(300n), .pd(25.2u),
 .ad(7.2p), .w(12u)) (*
integer library_binding = "gpdk090";
integer
passed_mfactor = "m";
 *)
PM13 ( Isource1_tt1p26mA, vbiaspc_output,
net113, AVDD_2p5V );
gpdk090_pmos2v #(.ps(25.2u), .m(1 * 1), .as(7.2p), .l(500n), .pd(25.2u),
 .ad(7.2p), .w(12u)) (*
integer library_binding = "gpdk090";
integer
passed_mfactor = "m";
 *)
PM14 ( net113, vbiasp_output, AVDD_2p5V,
AVDD_2p5V );

endmodule
