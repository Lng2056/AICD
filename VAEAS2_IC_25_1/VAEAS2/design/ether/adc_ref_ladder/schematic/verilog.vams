// Verilog-AMS netlist generated by the AMS netlister, version ICOA5.2.51.500.7.
// Cadence Design Systems, Inc.

`include "disciplines.vams"

module adc_ref_ladder ( ref0,ref1,ref10,ref2,ref3,ref4,ref5,ref6,ref7,
ref8,ref9,INM,INP,SIDDQ,VDD,VSS,ibias50 );

output   ref0;
output   ref1;
output   ref10;
output   ref2;
output
 ref3;
output   ref4;
output   ref5;
output   ref6;
output   ref7;

output   ref8;
output   ref9;
input   INM;
input   INP;
input
 SIDDQ;
input   VDD;
input   VSS;
input   ibias50;

parameter voffset=0;
parameter r_ladder=50;

gpdk090_resnsppoly #(.w(8u), .r(509.716), .l(10.185u)) (*
integer
library_binding = "gpdk090";
 *)
R14 ( ref10, ref10, VDD );
gpdk090_resnsppoly #(.w(8u), .r(509.716), .l(10.185u)) (*
integer
library_binding = "gpdk090";
 *)
R15 ( ref10, ref9, VDD );
gpdk090_resnsppoly #(.w(8u), .r(509.716), .l(10.185u)) (*
integer
library_binding = "gpdk090";
 *)
R16 ( ref9, ref8, VDD );
gpdk090_resnsppoly #(.w(8u), .r(509.716), .l(10.185u)) (*
integer
library_binding = "gpdk090";
 *)
R17 ( ref8, ref7, VDD );
gpdk090_resnsppoly #(.w(8u), .r(509.716), .l(10.185u)) (*
integer
library_binding = "gpdk090";
 *)
R18 ( ref7, ref6, VDD );
gpdk090_resnsppoly #(.w(8u), .r(509.716), .l(10.185u)) (*
integer
library_binding = "gpdk090";
 *)
R19 ( ref6, ref5, VDD );
gpdk090_resnsppoly #(.w(8u), .r(509.716), .l(10.185u)) (*
integer
library_binding = "gpdk090";
 *)
R20 ( ref5, ref4, VDD );
gpdk090_resnsppoly #(.w(8u), .r(509.716), .l(10.185u)) (*
integer
library_binding = "gpdk090";
 *)
R21 ( ref4, ref3, VDD );
gpdk090_resnsppoly #(.w(8u), .r(509.716), .l(10.185u)) (*
integer
library_binding = "gpdk090";
 *)
R22 ( ref3, ref2, VDD );
gpdk090_resnsppoly #(.w(8u), .r(509.716), .l(10.185u)) (*
integer
library_binding = "gpdk090";
 *)
R23 ( ref2, ref1, VDD );
gpdk090_resnsppoly #(.w(8u), .r(509.716), .l(10.185u)) (*
integer
library_binding = "gpdk090";
 *)
R24 ( ref1, ref0, VDD );
gpdk090_resnsppoly #(.w(8u), .r(509.716), .l(10.185u)) (*
integer
library_binding = "gpdk090";
 *)
R25 ( ref0, ref0, VDD );
gpdk090_resnsppoly #(.w(2u), .r(19.9992K), .l(100.02u)) (*
integer
library_binding = "gpdk090";
 *)
R11 ( INM, net22, VDD );
gpdk090_resnsppoly #(.w(2u), .r(19.9992K), .l(100.02u)) (*
integer
library_binding = "gpdk090";
 *)
R1 ( INP, net22, VDD );

gpdk090_pmos2v #(.ps(21.63u), .m(1 * 40), .as(6.3p), .l(280.0n), .pd(20.6u),
 .ad(6p), .w(20u)) (*
integer library_binding = "gpdk090";
integer
passed_mfactor = "m";
 *)
PM0 ( VSS, net21, ref0, ref0 );

gpdk090_pmoscap2v #(.m(4 * 8), .l(6.575u), .w(6.165u)) (*
integer
library_binding = "gpdk090";
integer passed_mfactor = "m";
 *)
C0 (
VDD, net21, VDD, VDD );

gpdk090_nmoscap2v #(.m(10 * 5), .l(9.5u), .w(2.265u)) (*
integer
library_binding = "gpdk090";
integer passed_mfactor = "m";
 *)
M0 (
ref0, ref10, ref0, VSS );

adc_cascode_opamp (*
integer library_binding = "ether";
 *)

ADC_CASCODE_OPAMP ( .INP( net22 ), .SIDDQ( SIDDQ ), .INN( ref5 ), .IREF(
ibias50 ), .VDD( VDD ), .OUT( net21 ), .VSS( VSS ) );

endmodule
