// Verilog-AMS netlist generated by the AMS netlister, version ICOA5.2.51.500.7.
// Cadence Design Systems, Inc.

`include "disciplines.vams"

module blw_dac_bin2therm ( bin_in,reset,down,up );

input [6:0]  bin_in;
input   reset;
output [62:0]  down;

output [62:0]  up;

wire n_167;
wire n_161;
wire n_189;
wire n_171;
wire n_169;
wire n_176;
wire n_168;
wire n_180;
wire n_200;
wire [6:0] bin_in;
wire n_212;
wire n_179;
wire n_154;
wire [62:0] up;
wire n_186;
wire n_162;
wire reset;
wire n_160;
wire n_198;
wire n_177;
wire n_155;
wire n_210;
wire n_172;
wire n_166;
wire n_165;
wire down_431;
wire down_512;
wire n_173;
wire n_159;
wire n_164;
wire n_158;
wire [62:0] down;
wire down_270;
wire n_178;
wire up_324;
wire n_196;
wire n_163;
wire n_170;
wire n_175;
wire n_181;
wire n_156;
wire up_163;
wire n_174;
wire n_192;
wire n_185;
wire n_157;

NAND2X1 (*
integer library_binding = "gsclib090";
 *)
i_21 ( .Y( n_166 ),
.B( bin_in[4] ), .A( bin_in[2] ) );
NAND2X1 (*
integer library_binding = "gsclib090";
 *)
i_3746 ( .Y(
up[36] ), .B( up_324 ), .A( n_164 ) );
NAND2X1 (*
integer library_binding = "gsclib090";
 *)
i_20 ( .Y( n_165 ),
.B( bin_in[4] ), .A( bin_in[3] ) );
NAND2X1 (*
integer library_binding = "gsclib090";
 *)
i_4150 ( .Y(
up[40] ), .B( up_324 ), .A( n_165 ) );
NAND2X1 (*
integer library_binding = "gsclib090";
 *)
i_2534 ( .Y(
up[24] ), .B( up_163 ), .A( n_162 ) );
NAND2X1 (*
integer library_binding = "gsclib090";
 *)
i_18 ( .Y( n_163 ),
.B( bin_in[5] ), .A( bin_in[2] ) );
NAND2X1 (*
integer library_binding = "gsclib090";
 *)
i_17 ( .Y( n_162 ),
.B( bin_in[5] ), .A( bin_in[3] ) );
NAND2X1 (*
integer library_binding = "gsclib090";
 *)
i_2130 ( .Y(
up[20] ), .B( up_163 ), .A( n_161 ) );
NAND2X1 (*
integer library_binding = "gsclib090";
 *)
i_16 ( .Y( n_160 ),
.B( bin_in[3] ), .A( bin_in[2] ) );
NAND2X1 (*
integer library_binding = "gsclib090";
 *)
i_918 ( .Y(
up[8] ), .B( n_186 ), .A( n_155 ) );
NAND2X1 (*
integer library_binding = "gsclib090";
 *)
i_23 ( .Y( n_159 ),
.B( n_154 ), .A( bin_in[2] ) );
NAND2X1 (*
integer library_binding = "gsclib090";
 *)
i_12 ( .Y( n_155 ),
.B( n_154 ), .A( bin_in[3] ) );
NAND2X1 (*
integer library_binding = "gsclib090";
 *)
i_514 ( .Y(
up[4] ), .B( n_186 ), .A( n_156 ) );
NAND2X1 (*
integer library_binding = "gsclib090";
 *)
i_48182 ( .Y(
down[47] ), .B( n_154 ), .A( n_170 ) );
NAND2X1 (*
integer library_binding = "gsclib090";
 *)
i_15 ( .Y( n_157 ),
.B( bin_in[1] ), .A( bin_in[0] ) );
NAND2X1 (*
integer library_binding = "gsclib090";
 *)
i_4958 ( .Y(
up[48] ), .B( n_186 ), .A( n_167 ) );
NAND2X1 (*
integer library_binding = "gsclib090";
 *)
i_8142 ( .Y(
down[7] ), .B( n_192 ), .A( n_210 ) );
NAND2X1 (*
integer library_binding = "gsclib090";
 *)
i_28 ( .Y(
down[31] ), .B( n_192 ), .A( bin_in[5] ) );
NAND2X1 (*
integer library_binding = "gsclib090";
 *)
i_6170 ( .Y(
up[60] ), .B( n_169 ), .A( n_186 ) );

NAND3X1 (*
integer library_binding = "gsclib090";
 *)
i_4554 ( .C(
n_166 ), .Y( up[44] ), .B( up_324 ), .A( n_165 ) );
NAND3X1 (*
integer library_binding = "gsclib090";
 *)
i_2938 ( .C(
n_163 ), .Y( up[28] ), .B( up_163 ), .A( n_162 ) );
NAND3X1 (*
integer library_binding = "gsclib090";
 *)
i_22 ( .C(
bin_in[4] ), .Y( n_164 ), .B( bin_in[3] ), .A( bin_in[2] ) );
NAND3X1 (*
integer library_binding = "gsclib090";
 *)
i_19 ( .C(
bin_in[5] ), .Y( n_161 ), .B( bin_in[3] ), .A( bin_in[2] ) );
NAND3X1 (*
integer library_binding = "gsclib090";
 *)
i_5362 ( .C(
n_160 ), .Y( up[52] ), .B( n_186 ), .A( n_167 ) );
NAND3X1 (*
integer library_binding = "gsclib090";
 *)
i_1322 ( .C(
n_159 ), .Y( up[12] ), .B( n_186 ), .A( n_155 ) );
NAND3X1 (*
integer library_binding = "gsclib090";
 *)
i_13 ( .C(
bin_in[2] ), .Y( n_156 ), .B( n_154 ), .A( bin_in[3] ) );
NAND3X1 (*
integer library_binding = "gsclib090";
 *)
i_56190 ( .C(
n_170 ), .Y( down[55] ), .B( n_154 ), .A( bin_in[3] ) );
NAND3X1 (*
integer library_binding = "gsclib090";
 *)
i_12146 ( .C(
n_171 ), .Y( down[11] ), .B( n_192 ), .A( n_210 ) );

OAI211X1 (*
integer library_binding = "gsclib090";
 *)
i_3948 ( .C0(
up_324 ), .A0( n_165 ), .A1( n_189 ), .B0( n_164 ), .Y( up[38] ) );
OAI211X1 (*
integer library_binding = "gsclib090";
 *)
i_3847 ( .C0(
up_324 ), .A0( n_165 ), .A1( n_157 ), .B0( n_164 ), .Y( up[37] ) );
OAI211X1 (*
integer library_binding = "gsclib090";
 *)
i_4352 ( .C0(
up_324 ), .A0( n_166 ), .A1( n_189 ), .B0( n_165 ), .Y( up[42] ) );
OAI211X1 (*
integer library_binding = "gsclib090";
 *)
i_4453 ( .C0(
up_324 ), .A0( n_166 ), .A1( n_158 ), .B0( n_165 ), .Y( up[43] ) );
OAI211X1 (*
integer library_binding = "gsclib090";
 *)
i_4049 ( .C0(
up_324 ), .A0( n_165 ), .A1( n_158 ), .B0( n_164 ), .Y( up[39] ) );
OAI211X1 (*
integer library_binding = "gsclib090";
 *)
i_4251 ( .C0(
up_324 ), .A0( n_166 ), .A1( n_157 ), .B0( n_165 ), .Y( up[41] ) );
OAI211X1 (*
integer library_binding = "gsclib090";
 *)
i_2736 ( .C0(
up_163 ), .A0( n_163 ), .A1( n_189 ), .B0( n_162 ), .Y( up[26] ) );
OAI211X1 (*
integer library_binding = "gsclib090";
 *)
i_2635 ( .C0(
up_163 ), .A0( n_163 ), .A1( n_196 ), .B0( n_162 ), .Y( up[25] ) );
OAI211X1 (*
integer library_binding = "gsclib090";
 *)
i_2837 ( .C0(
up_163 ), .A0( n_163 ), .A1( n_200 ), .B0( n_162 ), .Y( up[27] ) );
OAI211X1 (*
integer library_binding = "gsclib090";
 *)
i_2433 ( .C0(
up_163 ), .A0( n_162 ), .A1( n_200 ), .B0( n_161 ), .Y( up[23] ) );
OAI211X1 (*
integer library_binding = "gsclib090";
 *)
i_2332 ( .C0(
up_163 ), .A0( n_162 ), .A1( n_189 ), .B0( n_161 ), .Y( up[22] ) );
OAI211X1 (*
integer library_binding = "gsclib090";
 *)
i_2231 ( .C0(
up_163 ), .A0( n_162 ), .A1( n_196 ), .B0( n_161 ), .Y( up[21] ) );
OAI211X1 (*
integer library_binding = "gsclib090";
 *)
i_5261 ( .C0(
n_186 ), .A0( n_160 ), .A1( n_158 ), .B0( n_167 ), .Y( up[51] ) );
OAI211X1 (*
integer library_binding = "gsclib090";
 *)
i_5160 ( .C0(
n_186 ), .A0( n_160 ), .A1( n_189 ), .B0( n_167 ), .Y( up[50] ) );
OAI211X1 (*
integer library_binding = "gsclib090";
 *)
i_5059 ( .C0(
n_186 ), .A0( n_160 ), .A1( n_157 ), .B0( n_167 ), .Y( up[49] ) );
OAI211X1 (*
integer library_binding = "gsclib090";
 *)
i_1221 ( .C0(
n_186 ), .A0( n_159 ), .A1( n_200 ), .B0( n_155 ), .Y( up[11] ) );
OAI211X1 (*
integer library_binding = "gsclib090";
 *)
i_1120 ( .C0(
n_186 ), .A0( n_159 ), .A1( n_189 ), .B0( n_155 ), .Y( up[10] ) );
OAI211X1 (*
integer library_binding = "gsclib090";
 *)
i_1019 ( .C0(
n_186 ), .A0( n_159 ), .A1( n_196 ), .B0( n_155 ), .Y( up[9] ) );
OAI211X1 (*
integer library_binding = "gsclib090";
 *)
i_817 ( .C0(
n_186 ), .A0( n_155 ), .A1( n_200 ), .B0( n_156 ), .Y( up[7] ) );
OAI211X1 (*
integer library_binding = "gsclib090";
 *)
i_716 ( .C0(
n_186 ), .A0( n_155 ), .A1( n_189 ), .B0( n_156 ), .Y( up[6] ) );
OAI211X1 (*
integer library_binding = "gsclib090";
 *)
i_615 ( .C0(
n_186 ), .A0( n_155 ), .A1( n_196 ), .B0( n_156 ), .Y( up[5] ) );
OAI211X1 (*
integer library_binding = "gsclib090";
 *)
i_9143 ( .C0(
n_192 ), .A0( n_171 ), .A1( n_180 ), .B0( n_210 ), .Y( down[8] ) );
OAI211X1 (*
integer library_binding = "gsclib090";
 *)
i_10144 ( .C0(
n_192 ), .A0( n_171 ), .A1( bin_in[1] ), .B0( n_210 ), .Y( down[9] ) );
OAI211X1 (*
integer library_binding = "gsclib090";
 *)
i_11145 ( .C0(
n_192 ), .A0( n_198 ), .A1( n_171 ), .B0( n_210 ), .Y( down[10] ) );

OAI21XL (*
integer library_binding = "gsclib090";
 *)
i_3544 ( .A0(
n_164 ), .A1( n_189 ), .B0( up_324 ), .Y( up[34] ) );
OAI21XL (*
integer library_binding = "gsclib090";
 *)
i_3645 ( .A0(
n_164 ), .A1( n_158 ), .B0( up_324 ), .Y( up[35] ) );
OAI21XL (*
integer library_binding = "gsclib090";
 *)
i_3443 ( .A0(
n_164 ), .A1( n_196 ), .B0( up_324 ), .Y( up[33] ) );
OAI21XL (*
integer library_binding = "gsclib090";
 *)
i_2029 ( .A0(
n_161 ), .A1( n_200 ), .B0( up_163 ), .Y( up[19] ) );
OAI21XL (*
integer library_binding = "gsclib090";
 *)
i_1928 ( .A0(
n_161 ), .A1( n_189 ), .B0( up_163 ), .Y( up[18] ) );
OAI21XL (*
integer library_binding = "gsclib090";
 *)
i_1827 ( .A0(
n_161 ), .A1( n_196 ), .B0( up_163 ), .Y( up[17] ) );
OAI21XL (*
integer library_binding = "gsclib090";
 *)
i_413 ( .A0(
n_156 ), .A1( n_200 ), .B0( n_186 ), .Y( up[3] ) );
OAI21XL (*
integer library_binding = "gsclib090";
 *)
i_211 ( .A0(
n_156 ), .A1( n_196 ), .B0( n_186 ), .Y( up[1] ) );
OAI21XL (*
integer library_binding = "gsclib090";
 *)
i_312 ( .A0(
n_156 ), .A1( n_189 ), .B0( n_186 ), .Y( up[2] ) );
OAI21XL (*
integer library_binding = "gsclib090";
 *)
i_47181 ( .A0(
bin_in[4] ), .A1( n_179 ), .B0( down_431 ), .Y( down[46] ) );
OAI21XL (*
integer library_binding = "gsclib090";
 *)
i_53187 ( .A0(
bin_in[3] ), .A1( n_180 ), .B0( down_512 ), .Y( down[52] ) );
OAI21XL (*
integer library_binding = "gsclib090";
 *)
i_55189 ( .A0(
bin_in[3] ), .A1( n_179 ), .B0( down_512 ), .Y( down[54] ) );
OAI21XL (*
integer library_binding = "gsclib090";
 *)
i_59193 ( .A0(
bin_in[2] ), .A1( n_179 ), .B0( n_185 ), .Y( down[58] ) );
OAI21XL (*
integer library_binding = "gsclib090";
 *)
i_57191 ( .A0(
bin_in[2] ), .A1( n_180 ), .B0( n_185 ), .Y( down[56] ) );
OAI21XL (*
integer library_binding = "gsclib090";
 *)
i_5139 ( .A0(
n_210 ), .A1( n_180 ), .B0( n_181 ), .Y( down[4] ) );
OAI21XL (*
integer library_binding = "gsclib090";
 *)
i_6140 ( .A0(
n_210 ), .A1( bin_in[1] ), .B0( n_181 ), .Y( down[5] ) );
OAI21XL (*
integer library_binding = "gsclib090";
 *)
i_7141 ( .A0(
n_210 ), .A1( n_198 ), .B0( n_181 ), .Y( down[6] ) );
OAI21XL (*
integer library_binding = "gsclib090";
 *)
i_30164 ( .A0(
bin_in[5] ), .A1( bin_in[1] ), .B0( down_270 ), .Y( down[29] ) );
OAI21XL (*
integer library_binding = "gsclib090";
 *)
i_31165 ( .A0(
n_198 ), .A1( bin_in[5] ), .B0( down_270 ), .Y( down[30] ) );
OAI21XL (*
integer library_binding = "gsclib090";
 *)
i_46180 ( .A0(
bin_in[4] ), .A1( bin_in[1] ), .B0( down_431 ), .Y( down[45] ) );
OAI21XL (*
integer library_binding = "gsclib090";
 *)
i_54188 ( .A0(
bin_in[3] ), .A1( bin_in[1] ), .B0( down_512 ), .Y( down[53] ) );
OAI21XL (*
integer library_binding = "gsclib090";
 *)
i_58192 ( .A0(
bin_in[2] ), .A1( bin_in[1] ), .B0( n_185 ), .Y( down[57] ) );
OAI21XL (*
integer library_binding = "gsclib090";
 *)
i_4138 ( .A0(
bin_in[2] ), .A1( n_210 ), .B0( n_192 ), .Y( down[3] ) );

NOR3X1 (*
integer library_binding = "gsclib090";
 *)
i_3 ( .C(
bin_in[5] ), .Y( n_173 ), .B( bin_in[3] ), .A( bin_in[2] ) );
NOR3X1 (*
integer library_binding = "gsclib090";
 *)
i_6 ( .C(
bin_in[4] ), .Y( n_176 ), .B( bin_in[3] ), .A( bin_in[2] ) );

AO21X1 (*
integer library_binding = "gsclib090";
 *)
i_17151 ( .A0(
n_173 ), .A1( n_200 ), .B0( down[15] ), .Y( down[16] ) );
AO21X1 (*
integer library_binding = "gsclib090";
 *)
i_18152 ( .A0(
n_173 ), .A1( n_189 ), .B0( down[15] ), .Y( down[17] ) );
AO21X1 (*
integer library_binding = "gsclib090";
 *)
i_19153 ( .A0(
n_173 ), .A1( n_196 ), .B0( down[15] ), .Y( down[18] ) );
AO21X1 (*
integer library_binding = "gsclib090";
 *)
i_21155 ( .A0(
n_174 ), .A1( n_200 ), .B0( down[19] ), .Y( down[20] ) );
AO21X1 (*
integer library_binding = "gsclib090";
 *)
i_22156 ( .A0(
n_174 ), .A1( n_189 ), .B0( down[19] ), .Y( down[21] ) );
AO21X1 (*
integer library_binding = "gsclib090";
 *)
i_23157 ( .A0(
n_174 ), .A1( n_196 ), .B0( down[19] ), .Y( down[22] ) );
AO21X1 (*
integer library_binding = "gsclib090";
 *)
i_33167 ( .A0(
n_176 ), .A1( n_158 ), .B0( down[31] ), .Y( down[32] ) );
AO21X1 (*
integer library_binding = "gsclib090";
 *)
i_34168 ( .A0(
n_176 ), .A1( n_189 ), .B0( down[31] ), .Y( down[33] ) );
AO21X1 (*
integer library_binding = "gsclib090";
 *)
i_35169 ( .A0(
n_176 ), .A1( n_196 ), .B0( down[31] ), .Y( down[34] ) );
AO21X1 (*
integer library_binding = "gsclib090";
 *)
i_13147 ( .A0(
n_167 ), .A1( n_200 ), .B0( down[11] ), .Y( down[12] ) );
AO21X1 (*
integer library_binding = "gsclib090";
 *)
i_15149 ( .A0(
n_167 ), .A1( n_196 ), .B0( down[11] ), .Y( down[14] ) );
AO21X1 (*
integer library_binding = "gsclib090";
 *)
i_25159 ( .A0(
n_175 ), .A1( n_200 ), .B0( down[23] ), .Y( down[24] ) );
AO21X1 (*
integer library_binding = "gsclib090";
 *)
i_27161 ( .A0(
n_175 ), .A1( n_196 ), .B0( down[23] ), .Y( down[26] ) );
AO21X1 (*
integer library_binding = "gsclib090";
 *)
i_39173 ( .A0(
n_177 ), .A1( n_196 ), .B0( down[35] ), .Y( down[38] ) );
AO21X1 (*
integer library_binding = "gsclib090";
 *)
i_37171 ( .A0(
n_177 ), .A1( n_158 ), .B0( down[35] ), .Y( down[36] ) );
AO21X1 (*
integer library_binding = "gsclib090";
 *)
i_38172 ( .A0(
n_177 ), .A1( n_189 ), .B0( down[35] ), .Y( down[37] ) );
AO21X1 (*
integer library_binding = "gsclib090";
 *)
i_1524 ( .A0(
bin_in[1] ), .A1( n_154 ), .B0( up[12] ), .Y( up[14] ) );
AO21X1 (*
integer library_binding = "gsclib090";
 *)
i_41175 ( .A0(
n_178 ), .A1( n_158 ), .B0( down[39] ), .Y( down[40] ) );
AO21X1 (*
integer library_binding = "gsclib090";
 *)
i_43177 ( .A0(
n_178 ), .A1( n_157 ), .B0( down[39] ), .Y( down[42] ) );
AO21X1 (*
integer library_binding = "gsclib090";
 *)
i_1625 ( .A0(
n_180 ), .A1( n_154 ), .B0( up[12] ), .Y( up[15] ) );
AO21X1 (*
integer library_binding = "gsclib090";
 *)
i_49183 ( .A0(
n_172 ), .A1( n_158 ), .B0( down[47] ), .Y( down[48] ) );
AO21X1 (*
integer library_binding = "gsclib090";
 *)
i_51185 ( .A0(
n_172 ), .A1( n_157 ), .B0( down[47] ), .Y( down[50] ) );
AO21X1 (*
integer library_binding = "gsclib090";
 *)
i_1423 ( .A0(
n_198 ), .A1( n_154 ), .B0( up[12] ), .Y( up[13] ) );
AO21X1 (*
integer library_binding = "gsclib090";
 *)
i_6069 ( .A0(
bin_in[2] ), .A1( n_180 ), .B0( up[56] ), .Y( up[59] ) );
AO21X1 (*
integer library_binding = "gsclib090";
 *)
i_5867 ( .A0(
bin_in[2] ), .A1( n_179 ), .B0( up[56] ), .Y( up[57] ) );
AO21X1 (*
integer library_binding = "gsclib090";
 *)
i_5665 ( .A0(
bin_in[3] ), .A1( n_180 ), .B0( up[52] ), .Y( up[55] ) );
AO21X1 (*
integer library_binding = "gsclib090";
 *)
i_5463 ( .A0(
bin_in[3] ), .A1( n_179 ), .B0( up[52] ), .Y( up[53] ) );
AO21X1 (*
integer library_binding = "gsclib090";
 *)
i_4857 ( .A0(
bin_in[4] ), .A1( n_180 ), .B0( up[44] ), .Y( up[47] ) );
AO21X1 (*
integer library_binding = "gsclib090";
 *)
i_4655 ( .A0(
bin_in[4] ), .A1( n_179 ), .B0( up[44] ), .Y( up[45] ) );
AO21X1 (*
integer library_binding = "gsclib090";
 *)
i_3241 ( .A0(
bin_in[5] ), .A1( n_180 ), .B0( up[28] ), .Y( up[31] ) );
AO21X1 (*
integer library_binding = "gsclib090";
 *)
i_14148 ( .A0(
n_167 ), .A1( n_189 ), .B0( down[11] ), .Y( down[13] ) );
AO21X1 (*
integer library_binding = "gsclib090";
 *)
i_42176 ( .A0(
n_178 ), .A1( n_189 ), .B0( down[39] ), .Y( down[41] ) );
AO21X1 (*
integer library_binding = "gsclib090";
 *)
i_50184 ( .A0(
n_172 ), .A1( n_189 ), .B0( down[47] ), .Y( down[49] ) );
AO21X1 (*
integer library_binding = "gsclib090";
 *)
i_26160 ( .A0(
n_175 ), .A1( n_189 ), .B0( down[23] ), .Y( down[25] ) );
AO21X1 (*
integer library_binding = "gsclib090";
 *)
i_5968 ( .A0(
bin_in[2] ), .A1( bin_in[1] ), .B0( up[56] ), .Y( up[58] ) );
AO21X1 (*
integer library_binding = "gsclib090";
 *)
i_5564 ( .A0(
bin_in[3] ), .A1( bin_in[1] ), .B0( up[52] ), .Y( up[54] ) );
AO21X1 (*
integer library_binding = "gsclib090";
 *)
i_4756 ( .A0(
bin_in[4] ), .A1( bin_in[1] ), .B0( up[44] ), .Y( up[46] ) );
AO21X1 (*
integer library_binding = "gsclib090";
 *)
i_3140 ( .A0(
bin_in[5] ), .A1( bin_in[1] ), .B0( up[28] ), .Y( up[30] ) );
AO21X1 (*
integer library_binding = "gsclib090";
 *)
i_3039 ( .A0(
bin_in[5] ), .A1( n_198 ), .B0( up[28] ), .Y( up[29] ) );

OR2X1 (*
integer library_binding = "gsclib090";
 *)
i_20154 ( .Y(
down[19] ), .B( down[15] ), .A( n_173 ) );
OR2X1 (*
integer library_binding = "gsclib090";
 *)
i_24158 ( .Y(
down[23] ), .B( down[15] ), .A( n_174 ) );
OR2X1 (*
integer library_binding = "gsclib090";
 *)
i_36170 ( .Y(
down[35] ), .B( down[31] ), .A( n_176 ) );
OR2X1 (*
integer library_binding = "gsclib090";
 *)
i_40174 ( .Y(
down[39] ), .B( down[31] ), .A( n_177 ) );

NOR2X1 (*
integer library_binding = "gsclib090";
 *)
i_1 ( .Y( n_174 ),
.B( bin_in[3] ), .A( bin_in[5] ) );
NOR2X1 (*
integer library_binding = "gsclib090";
 *)
i_4 ( .Y( n_177 ),
.B( bin_in[3] ), .A( bin_in[4] ) );
NOR2X1 (*
integer library_binding = "gsclib090";
 *)
i_26 ( .Y( up_324 ),
.B( n_212 ), .A( bin_in[5] ) );
NOR2X1 (*
integer library_binding = "gsclib090";
 *)
i_14 ( .Y( n_158 ),
.B( bin_in[1] ), .A( bin_in[0] ) );
NOR2X1 (*
integer library_binding = "gsclib090";
 *)
i_25 ( .Y( up_163 ),
.B( up[0] ), .A( n_154 ) );
NOR2X1 (*
integer library_binding = "gsclib090";
 *)
i_5 ( .Y( n_178 ),
.B( bin_in[2] ), .A( bin_in[4] ) );
NOR2X1 (*
integer library_binding = "gsclib090";
 *)
i_0 ( .Y( n_172 ),
.B( bin_in[3] ), .A( bin_in[2] ) );
NOR2X1 (*
integer library_binding = "gsclib090";
 *)
i_44178 ( .Y(
down_431 ), .B( down[39] ), .A( n_178 ) );
NOR2X1 (*
integer library_binding = "gsclib090";
 *)
i_52186 ( .Y(
down_512 ), .B( down[47] ), .A( n_172 ) );
NOR2X1 (*
integer library_binding = "gsclib090";
 *)
i_2 ( .Y( n_175 ),
.B( bin_in[2] ), .A( bin_in[5] ) );
NOR2X1 (*
integer library_binding = "gsclib090";
 *)
i_28162 ( .Y(
down_270 ), .B( down[23] ), .A( n_175 ) );
NOR2X1 (*
integer library_binding = "gsclib090";
 *)
i_8 ( .Y( n_169 ),
.B( n_210 ), .A( bin_in[2] ) );
NOR2X1 (*
integer library_binding = "gsclib090";
 *)
i_24 ( .Y( n_170 ),
.B( bin_in[6] ), .A( reset ) );

BUFX2 (*
integer library_binding = "gsclib090";
 *)
i_360 ( .Y( n_200 ),
.A( n_158 ) );
BUFX2 (*
integer library_binding = "gsclib090";
 *)
i_356 ( .Y( n_196 ),
.A( n_157 ) );
BUFX2 (*
integer library_binding = "gsclib090";
 *)
i_352 ( .Y( n_192 ),
.A( n_170 ) );
BUFX2 (*
integer library_binding = "gsclib090";
 *)
i_372 ( .Y( up[0] ),
.A( n_212 ) );
BUFX2 (*
integer library_binding = "gsclib090";
 *)
i_358 ( .Y( n_198 ),
.A( n_179 ) );

NAND2BX2 (*
integer library_binding = "gsclib090";
 *)
i_60194 ( .AN(
n_156 ), .Y( down[59] ), .B( n_192 ) );

NAND2BX1 (*
integer library_binding = "gsclib090";
 *)
i_6271 ( .AN(
up[60] ), .Y( up[61] ), .B( n_157 ) );
NAND2BX1 (*
integer library_binding = "gsclib090";
 *)
i_7 ( .AN(
bin_in[2] ), .Y( n_171 ), .B( n_167 ) );
NAND2BX1 (*
integer library_binding = "gsclib090";
 *)
i_63197 ( .AN(
down[59] ), .Y( down[62] ), .B( n_179 ) );
NAND2BX1 (*
integer library_binding = "gsclib090";
 *)
i_61195 ( .AN(
down[59] ), .Y( down[60] ), .B( n_180 ) );
NAND2BX1 (*
integer library_binding = "gsclib090";
 *)
i_63 ( .AN(
up[60] ), .Y( up[62] ), .B( n_189 ) );
NAND2BX1 (*
integer library_binding = "gsclib090";
 *)
i_5766 ( .AN(
n_210 ), .Y( up[56] ), .B( n_186 ) );
NAND2BX1 (*
integer library_binding = "gsclib090";
 *)
i_62196 ( .AN(
down[59] ), .Y( down[61] ), .B( bin_in[1] ) );
NAND2BX1 (*
integer library_binding = "gsclib090";
 *)
i_9 ( .AN(
bin_in[3] ), .Y( n_168 ), .B( n_167 ) );
NAND2BX1 (*
integer library_binding = "gsclib090";
 *)
i_110 ( .AN(
reset ), .Y( n_212 ), .B( bin_in[6] ) );

AND2X2 (*
integer library_binding = "gsclib090";
 *)
i_11 ( .Y( n_154 ),
.B( bin_in[4] ), .A( bin_in[5] ) );

INVX3 (*
integer library_binding = "gsclib090";
 *)
i_340 ( .Y( n_180 ),
.A( n_158 ) );
INVX3 (*
integer library_binding = "gsclib090";
 *)
i_346 ( .Y( n_186 ),
.A( up[0] ) );
INVX3 (*
integer library_binding = "gsclib090";
 *)
i_349 ( .Y( n_189 ),
.A( bin_in[1] ) );

CLKINVX1 (*
integer library_binding = "gsclib090";
 *)
i_339 ( .Y(
n_179 ), .A( n_157 ) );
CLKINVX1 (*
integer library_binding = "gsclib090";
 *)
i_341 ( .Y(
n_181 ), .A( down[3] ) );
CLKINVX1 (*
integer library_binding = "gsclib090";
 *)
i_342 ( .Y(
down[27] ), .A( down_270 ) );
CLKINVX1 (*
integer library_binding = "gsclib090";
 *)
i_343 ( .Y(
down[43] ), .A( down_431 ) );
CLKINVX1 (*
integer library_binding = "gsclib090";
 *)
i_344 ( .Y(
down[51] ), .A( down_512 ) );
CLKINVX1 (*
integer library_binding = "gsclib090";
 *)
i_345 ( .Y(
n_185 ), .A( down[55] ) );
CLKINVX1 (*
integer library_binding = "gsclib090";
 *)
i_347 ( .Y(
up[16] ), .A( up_163 ) );
CLKINVX1 (*
integer library_binding = "gsclib090";
 *)
i_348 ( .Y(
up[32] ), .A( up_324 ) );

OAI31XL (*
integer library_binding = "gsclib090";
 *)
i_1135 ( .A0(
bin_in[2] ), .A1( n_210 ), .B0( n_192 ), .Y( down[0] ), .A2( n_180 ) );
OAI31XL (*
integer library_binding = "gsclib090";
 *)
i_29163 ( .A0(
bin_in[0] ), .A1( bin_in[1] ), .B0( down_270 ), .Y( down[28] ), .A2(
bin_in[5] ) );
OAI31XL (*
integer library_binding = "gsclib090";
 *)
i_45179 ( .A0(
bin_in[0] ), .A1( bin_in[1] ), .B0( down_431 ), .Y( down[44] ), .A2(
bin_in[4] ) );
OAI31XL (*
integer library_binding = "gsclib090";
 *)
i_2136 ( .A0(
bin_in[2] ), .A1( n_210 ), .B0( n_192 ), .Y( down[1] ), .A2( bin_in[1] ) );
OAI31XL (*
integer library_binding = "gsclib090";
 *)
i_3137 ( .A0(
bin_in[2] ), .A1( n_210 ), .B0( n_192 ), .Y( down[2] ), .A2( n_198 ) );

NOR2X2 (*
integer library_binding = "gsclib090";
 *)
i_10 ( .Y( n_167 ),
.B( bin_in[4] ), .A( bin_in[5] ) );

OAI21X1 (*
integer library_binding = "gsclib090";
 *)
i_27 ( .A0(
bin_in[5] ), .A1( bin_in[4] ), .B0( n_192 ), .Y( down[15] ) );

CLKBUFX3 (*
integer library_binding = "gsclib090";
 *)
i_370 ( .Y(
n_210 ), .A( n_168 ) );

endmodule
