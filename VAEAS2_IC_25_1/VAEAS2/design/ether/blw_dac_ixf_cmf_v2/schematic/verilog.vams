// Verilog-AMS netlist generated by the AMS netlister, version ICOA5.2.51.500.7.
// Cadence Design Systems, Inc.

`include "disciplines.vams"

module blw_dac_ixf_cmf_v2 ( Vref,Vbiasp,AVDD_2p5V,Vbiasn,Vbiaspc,vcm,
Vcm_sense,siddq,Vbiasnc,AGND,Ixf_m,Ixf_p );

input   Vref;
input   Vbiasp;
input   AVDD_2p5V;
input   Vbiasn;

input   Vbiaspc;
input   vcm;
input   Vcm_sense;
input   siddq;

input   Vbiasnc;
input   AGND;
output   Ixf_m;
output   Ixf_p;

gpdk090_pmos2v #(.ps(25.2u), .m(5 * 2), .as(7.2p), .l(500n), .pd(12.6u),
 .ad(3.6p), .w(12u)) (*
integer library_binding = "gpdk090";
integer
passed_mfactor = "m";
 *)
PM2 ( net068, Vbiasp, AVDD_2p5V, AVDD_2p5V );
gpdk090_pmos2v #(.ps(3.53u), .m(1 * 2), .as(699f), .l(280.0n), .pd(1.765u),
 .ad(349.5f), .w(1.165u)) (*
integer library_binding = "gpdk090";

integer passed_mfactor = "m";
 *)
PM11 ( net0156, net099, AVDD_2p5V,
AVDD_2p5V );
gpdk090_pmos2v #(.ps(3.53u), .m(1 * 2), .as(699f), .l(280.0n), .pd(1.765u),
 .ad(349.5f), .w(1.165u)) (*
integer library_binding = "gpdk090";

integer passed_mfactor = "m";
 *)
PM12 ( net0136, net0103, AVDD_2p5V,
AVDD_2p5V );
gpdk090_pmos2v #(.ps(2.8u), .m(1 * 1), .as(440f), .l(300n), .pd(2.8u),
 .ad(440f), .w(400n)) (*
integer library_binding = "gpdk090";
integer
passed_mfactor = "m";
 *)
PM5 ( on, siddq, AVDD_2p5V, AVDD_2p5V );
gpdk090_pmos2v #(.ps(3.2u), .m(1 * 1), .as(600f), .l(300n), .pd(3.2u),
 .ad(600f), .w(1u)) (*
integer library_binding = "gpdk090";
integer
passed_mfactor = "m";
 *)
PM13 ( net0103, on, AVDD_2p5V, AVDD_2p5V );
gpdk090_pmos2v #(.ps(2.8u), .m(1 * 1), .as(440f), .l(300n), .pd(2.8u),
 .ad(440f), .w(400n)) (*
integer library_binding = "gpdk090";
integer
passed_mfactor = "m";
 *)
PM6 ( off, on, AVDD_2p5V, AVDD_2p5V );
gpdk090_pmos2v #(.ps(25.2u), .m(5 * 2), .as(7.2p), .l(300n), .pd(12.6u),
 .ad(3.6p), .w(12u)) (*
integer library_binding = "gpdk090";
integer
passed_mfactor = "m";
 *)
PM3 ( Ixf_p, Vbiaspc, net068, AVDD_2p5V );
gpdk090_pmos2v #(.ps(25.2u), .m(5 * 2), .as(7.2p), .l(300n), .pd(12.6u),
 .ad(3.6p), .w(12u)) (*
integer library_binding = "gpdk090";
integer
passed_mfactor = "m";
 *)
PM4 ( Ixf_m, Vbiaspc, net060, AVDD_2p5V );
gpdk090_pmos2v #(.ps(3.53u), .m(1 * 2), .as(699f), .l(280.0n), .pd(1.765u),
 .ad(349.5f), .w(1.165u)) (*
integer library_binding = "gpdk090";

integer passed_mfactor = "m";
 *)
PM9 ( net0103, net0103, AVDD_2p5V,
AVDD_2p5V );
gpdk090_pmos2v #(.ps(3.53u), .m(1 * 2), .as(699f), .l(280.0n), .pd(1.765u),
 .ad(349.5f), .w(1.165u)) (*
integer library_binding = "gpdk090";

integer passed_mfactor = "m";
 *)
PM10 ( net099, net099, AVDD_2p5V,
AVDD_2p5V );
gpdk090_pmos2v #(.ps(25.2u), .m(5 * 2), .as(7.2p), .l(500n), .pd(12.6u),
 .ad(3.6p), .w(12u)) (*
integer library_binding = "gpdk090";
integer
passed_mfactor = "m";
 *)
PM0 ( net060, Vbiasp, AVDD_2p5V, AVDD_2p5V );
gpdk090_pmos2v #(.ps(3.2u), .m(1 * 1), .as(600f), .l(300n), .pd(3.2u),
 .ad(600f), .w(1u)) (*
integer library_binding = "gpdk090";
integer
passed_mfactor = "m";
 *)
PM14 ( net099, on, AVDD_2p5V, AVDD_2p5V );

gpdk090_nmos2v #(.ps(13.2u), .m(12 * 2), .as(3.6p), .l(280.0n), .pd(6.6u),
 .ad(1.8p), .w(6u)) (*
integer library_binding = "gpdk090";
integer
passed_mfactor = "m";
 *)
NM0 ( net0146, net0156, AGND, AGND );
gpdk090_nmos2v #(.ps(2.8u), .m(1 * 1), .as(440f), .l(350.0n), .pd(2.8u),
 .ad(440f), .w(400n)) (*
integer library_binding = "gpdk090";
integer
passed_mfactor = "m";
 *)
NM5 ( on, siddq, AGND, AGND );
gpdk090_nmos2v #(.ps(2.4u), .m(1 * 2), .as(360f), .l(280.0n), .pd(1.2u),
 .ad(180f), .w(600n)) (*
integer library_binding = "gpdk090";
integer
passed_mfactor = "m";
 *)
NM11 ( net0136, net0136, AGND, AGND );
gpdk090_nmos2v #(.ps(3.2u), .m(1 * 1), .as(600f), .l(350.0n), .pd(3.2u),
 .ad(600f), .w(1u)) (*
integer library_binding = "gpdk090";
integer
passed_mfactor = "m";
 *)
PM1 ( net0156, off, AGND, AGND );
gpdk090_nmos2v #(.ps(1.01u), .m(1 * 2), .as(72.6f), .l(350.0n), .pd(2.6u),
 .ad(600f), .w(150n)) (*
integer library_binding = "gpdk090";
integer
passed_mfactor = "m";
 *)
NM9 ( net0103, Vref, net0102, AGND );
gpdk090_nmos2v #(.ps(6.53333u), .m(4 * 12), .as(1.75p), .l(350.0n), .pd(5.6u),
 .ad(1.5p), .w(5u)) (*
integer library_binding = "gpdk090";
integer
passed_mfactor = "m";
 *)
NM3 ( Ixf_m, Vbiasnc, net0146, AGND );
gpdk090_nmos2v #(.ps(6.53333u), .m(4 * 12), .as(1.75p), .l(350.0n), .pd(5.6u),
 .ad(1.5p), .w(5u)) (*
integer library_binding = "gpdk090";
integer
passed_mfactor = "m";
 *)
NM4 ( Ixf_p, Vbiasnc, net0130, AGND );
gpdk090_nmos2v #(.ps(2.4u), .m(1 * 2), .as(360f), .l(280.0n), .pd(1.2u),
 .ad(180f), .w(600n)) (*
integer library_binding = "gpdk090";
integer
passed_mfactor = "m";
 *)
NM12 ( net0156, net0136, AGND, AGND );
gpdk090_nmos2v #(.ps(1.01u), .m(1 * 2), .as(72.6f), .l(350.0n), .pd(2.6u),
 .ad(600f), .w(150n)) (*
integer library_binding = "gpdk090";
integer
passed_mfactor = "m";
 *)
NM10 ( net099, Vcm_sense, net0102, AGND );
gpdk090_nmos2v #(.ps(8.4u), .m(1 * 4), .as(2.25p), .l(5u), .pd(5.6u),
.ad(1.5p), .w(5u)) (*
integer library_binding = "gpdk090";
integer
passed_mfactor = "m";
 *)
NM6 ( net0102, Vbiasn, AGND, AGND );
gpdk090_nmos2v #(.ps(13.2u), .m(12 * 2), .as(3.6p), .l(280.0n), .pd(6.6u),
 .ad(1.8p), .w(6u)) (*
integer library_binding = "gpdk090";
integer
passed_mfactor = "m";
 *)
NM1 ( net0130, net0156, AGND, AGND );
gpdk090_nmos2v #(.ps(2.8u), .m(1 * 1), .as(440f), .l(350.0n), .pd(2.8u),
 .ad(440f), .w(400n)) (*
integer library_binding = "gpdk090";
integer
passed_mfactor = "m";
 *)
NM7 ( off, on, AGND, AGND );
gpdk090_nmos2v #(.ps(5.175u), .m(3 * 16), .as(1.35p), .l(1u), .pd(4.6u),
 .ad(72.6f), .w(4u)) (*
integer library_binding = "gpdk090";
integer
passed_mfactor = "m";
 *)
NM2 ( net0156, vcm, net0156, AGND );
gpdk090_nmos2v #(.ps(3.2u), .m(1 * 1), .as(600f), .l(350.0n), .pd(3.2u),
 .ad(600f), .w(1u)) (*
integer library_binding = "gpdk090";
integer
passed_mfactor = "m";
 *)
NM16 ( net0136, off, AGND, AGND );

gpdk090_nmoscap2v #(.m(2 * 16), .l(2.27u), .w(2.265u)) (*
integer
library_binding = "gpdk090";
integer passed_mfactor = "m";
 *)
C0 (
AGND, net0156, AGND, AGND );

endmodule
