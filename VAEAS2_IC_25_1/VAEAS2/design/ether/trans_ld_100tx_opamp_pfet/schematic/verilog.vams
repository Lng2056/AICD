// Verilog-AMS netlist generated by the AMS netlister, version ICOA5.2.51.500.7.
// Cadence Design Systems, Inc.

`include "disciplines.vams"

module trans_ld_100tx_opamp_pfet ( ibias,inp,vss,vdd,siddq,inm,out );

input   ibias;
input   inp;
input   vss;
input   vdd;
input   siddq;

input   inm;
output   out;

gpdk090_pmos2v #(.ps(38.4u), .m(1 * 4), .as(11.25p), .l(2u), .pd(25.6u),
 .ad(7.5p), .w(25u)) (*
integer library_binding = "gpdk090";
integer
passed_mfactor = "m";
 *)
PM2 ( net78, net78, vdd, vdd );
gpdk090_pmos2v #(.ps(32u), .m(1 * 8), .as(9.375p), .l(2u), .pd(25.6u),
 .ad(7.5p), .w(25u)) (*
integer library_binding = "gpdk090";
integer
passed_mfactor = "m";
 *)
PM3 ( net79, net78, vdd, vdd );
gpdk090_pmos2v #(.ps(23.4u), .m(2 * 4), .as(6.75p), .l(1u), .pd(15.6u),
 .ad(4.5p), .w(15u)) (*
integer library_binding = "gpdk090";
integer
passed_mfactor = "m";
 *)
PM5 ( net32, inp, net79, vdd );
gpdk090_pmos2v #(.ps(23.4u), .m(2 * 4), .as(6.75p), .l(1u), .pd(15.6u),
 .ad(4.5p), .w(15u)) (*
integer library_binding = "gpdk090";
integer
passed_mfactor = "m";
 *)
PM6 ( net24, inm, net79, vdd );
gpdk090_pmos2v #(.ps(3.53u), .m(1 * 1), .as(699f), .l(280.0n), .pd(3.53u),
 .ad(699f), .w(1.165u)) (*
integer library_binding = "gpdk090";

integer passed_mfactor = "m";
 *)
PM7 ( net78, siddq_n, vdd, vdd );
gpdk090_pmos2v #(.ps(51.2u), .m(1 * 1), .as(15p), .l(2u), .pd(51.2u),
.ad(15p), .w(25u)) (*
integer library_binding = "gpdk090";
integer
passed_mfactor = "m";
 *)
PM10 ( net20, net20, vdd, vdd );
gpdk090_pmos2v #(.ps(51.2u), .m(1 * 1), .as(15p), .l(2u), .pd(51.2u),
.ad(15p), .w(25u)) (*
integer library_binding = "gpdk090";
integer
passed_mfactor = "m";
 *)
PM12 ( out, net20, vdd, vdd );
gpdk090_pmos2v #(.ps(32u), .m(1 * 8), .as(9.375p), .l(2u), .pd(25.6u),
 .ad(7.5p), .w(25u)) (*
integer library_binding = "gpdk090";
integer
passed_mfactor = "m";
 *)
PM13 ( net12, net78, vdd, vdd );
gpdk090_pmos2v #(.ps(3.53u), .m(1 * 1), .as(699f), .l(280.0n), .pd(3.53u),
 .ad(699f), .w(1.165u)) (*
integer library_binding = "gpdk090";

integer passed_mfactor = "m";
 *)
PM9 ( vdd, siddq_n, net20, vdd );
gpdk090_pmos2v #(.ps(3.53u), .m(1 * 1), .as(699f), .l(280.0n), .pd(3.53u),
 .ad(699f), .w(1.165u)) (*
integer library_binding = "gpdk090";

integer passed_mfactor = "m";
 *)
PM8 ( vdd, siddq_n, net79, vdd );

gpdk090_nmos2v #(.ps(11.4667u), .m(1 * 6), .as(3.2p), .l(4u), .pd(8.6u),
 .ad(2.4p), .w(8u)) (*
integer library_binding = "gpdk090";
integer
passed_mfactor = "m";
 *)
NM0 ( net32, ibias, vss, vss );
gpdk090_nmos2v #(.ps(11.4667u), .m(1 * 6), .as(3.2p), .l(4u), .pd(8.6u),
 .ad(2.4p), .w(8u)) (*
integer library_binding = "gpdk090";
integer
passed_mfactor = "m";
 *)
NM1 ( net24, ibias, vss, vss );
gpdk090_nmos2v #(.ps(3.53u), .m(1 * 1), .as(699f), .l(280.0n), .pd(3.53u),
 .ad(699f), .w(1.165u)) (*
integer library_binding = "gpdk090";

integer passed_mfactor = "m";
 *)
NM10 ( ibias, siddq, vss, vss );
gpdk090_nmos2v #(.ps(17.2u), .m(1 * 1), .as(4.8p), .l(500n), .pd(17.2u),
 .ad(4.8p), .w(8u)) (*
integer library_binding = "gpdk090";
integer
passed_mfactor = "m";
 *)
NM6 ( net20, net12, net32, vss );
gpdk090_nmos2v #(.ps(12.9u), .m(1 * 4), .as(3.6p), .l(4u), .pd(8.6u),
.ad(2.4p), .w(8u)) (*
integer library_binding = "gpdk090";
integer
passed_mfactor = "m";
 *)
NM9 ( net78, ibias, vss, vss );
gpdk090_nmos2v #(.ps(12.9u), .m(1 * 4), .as(3.6p), .l(4u), .pd(8.6u),
.ad(2.4p), .w(8u)) (*
integer library_binding = "gpdk090";
integer
passed_mfactor = "m";
 *)
NM7 ( ibias, ibias, vss, vss );
gpdk090_nmos2v #(.ps(3.53u), .m(1 * 1), .as(699f), .l(280.0n), .pd(3.53u),
 .ad(699f), .w(1.165u)) (*
integer library_binding = "gpdk090";

integer passed_mfactor = "m";
 *)
NM8 ( net12, siddq, vss, vss );
gpdk090_nmos2v #(.ps(17.2u), .m(1 * 1), .as(4.8p), .l(500n), .pd(17.2u),
 .ad(4.8p), .w(8u)) (*
integer library_binding = "gpdk090";
integer
passed_mfactor = "m";
 *)
NM5 ( out, net12, net24, vss );

inv_1x_hv #(.ieLib("umc05001")) (*
integer library_binding = "ether";

integer cds_net_set[0:1] = { "DVDD","DVSS" };
integer DVDD = "vdd";

integer DVSS = "vss";
 *)
I4 ( .Y( siddq_n ), .A( siddq ) );

trans_ld_100tx_opamp_pfet_casv (*
integer library_binding = "ether";

 *)
I2 ( .S( vss ), .D( net12 ), .G( net12 ), .B( vss ) );

endmodule
