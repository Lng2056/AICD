// Verilog-AMS netlist generated by the AMS netlister, version ICOA5.2.51.500.7.
// Cadence Design Systems, Inc.

`include "disciplines.vams"

module PLL_NDVR ( DNn,VREF,IPLY_25u,DNp,VDD,PD,VSS,DN,FB_IN,FB_OUT );

output   DNn;
output   VREF;
input   IPLY_25u;
output   DNp;
input
 VDD;
input   PD;
input   VSS;
input   DN;
input   FB_IN;
output
 FB_OUT;

gpdk090_resnsppoly #(.w(2u), .r(2.19933K), .l(10.985u)) (*
integer
library_binding = "gpdk090";
 *)
R7 ( DNp, net147, VSS );
gpdk090_resnsppoly #(.w(2u), .r(999.368), .l(4.985u)) (*
integer
library_binding = "gpdk090";
 *)
R0 ( net099, VSS, VSS );
gpdk090_resnsppoly #(.w(2u), .r(2.19933K), .l(10.985u)) (*
integer
library_binding = "gpdk090";
 *)
R13 ( net136, VSS, VSS );
gpdk090_resnsppoly #(.w(2u), .r(2.19933K), .l(10.985u)) (*
integer
library_binding = "gpdk090";
 *)
R12 ( VREF, net136, VSS );
gpdk090_resnsppoly #(.w(2u), .r(2.19933K), .l(10.985u)) (*
integer
library_binding = "gpdk090";
 *)
R9 ( net147, VSS, VSS );
gpdk090_resnsppoly #(.w(2u), .r(2.19933K), .l(10.985u)) (*
integer
library_binding = "gpdk090";
 *)
R8 ( DNn, net147, VSS );
gpdk090_resnsppoly #(.w(2u), .r(8.79731K), .l(43.9829u)) (*
integer
library_binding = "gpdk090";
 *)
R6 ( FB_OUT, VSS, VSS );

gpdk090_nmos2v #(.ps(3.2u), .m(1 * 1), .as(600f), .l(280.0n), .pd(3.2u),
 .ad(600f), .w(1u)) (*
integer library_binding = "gpdk090";
integer
passed_mfactor = "m";
 *)
NM4 ( IPLY_25u, SLEEP, VSS, VSS );
gpdk090_nmos2v #(.ps(13.2u), .m(1 * 1), .as(3.6p), .l(280.0n), .pd(13.2u),
 .ad(3.6p), .w(6u)) (*
integer library_binding = "gpdk090";
integer
passed_mfactor = "m";
 *)
NM2 ( IPLY_25u, FB_IN, VSS, VSS );
gpdk090_nmos2v #(.ps(21.2u), .m(1 * 1), .as(6p), .l(5u), .pd(21.2u), .ad(6p),
 .w(10u)) (*
integer library_binding = "gpdk090";
integer
passed_mfactor = "m";
 *)
NM3 ( net93, IPLY_25u, VSS, VSS );

gpdk090_pmos2v #(.ps(18.9u), .m(1 * 4), .as(5.4p), .l(280.0n), .pd(12.6u),
 .ad(3.6p), .w(12u)) (*
integer library_binding = "gpdk090";
integer
passed_mfactor = "m";
 *)
PM11 ( DNp, s1, net106, VDD );
gpdk090_pmos2v #(.ps(18.9u), .m(1 * 4), .as(5.4p), .l(280.0n), .pd(12.6u),
 .ad(3.6p), .w(12u)) (*
integer library_binding = "gpdk090";
integer
passed_mfactor = "m";
 *)
PM14 ( VREF, net099, net98, VDD );
gpdk090_pmos2v #(.ps(13.25u), .m(1 * 8), .as(3.75p), .l(1u), .pd(10.6u),
 .ad(3p), .w(10u)) (*
integer library_binding = "gpdk090";
integer
passed_mfactor = "m";
 *)
PM13 ( net98, net93, VDD, VDD );
gpdk090_pmos2v #(.ps(13.25u), .m(1 * 8), .as(3.75p), .l(1u), .pd(10.6u),
 .ad(3p), .w(10u)) (*
integer library_binding = "gpdk090";
integer
passed_mfactor = "m";
 *)
PM10 ( net106, net93, VDD, VDD );
gpdk090_pmos2v #(.ps(21.2u), .m(1 * 2), .as(6p), .l(1u), .pd(10.6u), .ad(3p),
 .w(10u)) (*
integer library_binding = "gpdk090";
integer
passed_mfactor = "m";
 *)
PM9 ( net93, net93, VDD, VDD );
gpdk090_pmos2v #(.ps(21.2u), .m(1 * 2), .as(6p), .l(1u), .pd(10.6u), .ad(3p),
 .w(10u)) (*
integer library_binding = "gpdk090";
integer
passed_mfactor = "m";
 *)
PM8 ( FB_OUT, net93, VDD, VDD );
gpdk090_pmos2v #(.ps(3.2u), .m(1 * 1), .as(600f), .l(280.0n), .pd(3.2u),
 .ad(600f), .w(1u)) (*
integer library_binding = "gpdk090";
integer
passed_mfactor = "m";
 *)
PM15 ( net93, SLEEPb, VDD, VDD );
gpdk090_pmos2v #(.ps(18.9u), .m(1 * 4), .as(5.4p), .l(280.0n), .pd(12.6u),
 .ad(3.6p), .w(12u)) (*
integer library_binding = "gpdk090";
integer
passed_mfactor = "m";
 *)
PM12 ( DNn, s1b, net106, VDD );

gpdk090_nmoscap2v #(.m(1 * 10), .l(4.07u), .w(4.055u)) (*
integer
library_binding = "gpdk090";
integer passed_mfactor = "m";
 *)
C6 (
VSS, net147, VSS, VSS );
gpdk090_nmoscap2v #(.m(1 * 80), .l(4.07u), .w(4.06u)) (*
integer
library_binding = "gpdk090";
integer passed_mfactor = "m";
 *)
C4 (
VSS, IPLY_25u, VSS, VSS );
gpdk090_nmoscap2v #(.m(1 * 10), .l(4.07u), .w(4.055u)) (*
integer
library_binding = "gpdk090";
integer passed_mfactor = "m";
 *)
C7 (
VSS, VREF, VSS, VSS );

PLL_INV10X (*
integer library_binding = "ether";
 *)
I23 ( .VDD( VDD ),
.Y( s1 ), .VSS( VSS ), .A( s1b ) );
PLL_INV10X (*
integer library_binding = "ether";
 *)
I24 ( .VDD( VDD ),
.Y( net57 ), .VSS( VSS ), .A( s1 ) );
PLL_INV10X (*
integer library_binding = "ether";
 *)
I15 ( .VDD( VDD ),
.Y( s1b ), .VSS( VSS ), .A( net73 ) );

PLL_INV3X (*
integer library_binding = "ether";
 *)
I25 ( .VDD( VDD ),
.Y( SLEEPb ), .VSS( VSS ), .A( PD ) );
PLL_INV3X (*
integer library_binding = "ether";
 *)
I26 ( .VDD( VDD ),
.Y( SLEEP ), .VSS( VSS ), .A( SLEEPb ) );
PLL_INV3X (*
integer library_binding = "ether";
 *)
I14 ( .VDD( VDD ),
.Y( net73 ), .VSS( VSS ), .A( DN ) );

endmodule
