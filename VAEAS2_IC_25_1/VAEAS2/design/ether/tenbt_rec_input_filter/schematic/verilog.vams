// Verilog-AMS netlist generated by the AMS netlister, version ICOA5.2.51.500.7.
// Cadence Design Systems, Inc.

`include "disciplines.vams"

module tenbt_rec_input_filter ( out_neg,INP,out_pos,vss,vdd,Vbias_Poly,
input_filter_off,INN,siddq );

output   out_neg;
input   INP;
output   out_pos;
input   vss;
input
 vdd;
input   Vbias_Poly;
input   input_filter_off;
input   INN;

input   siddq;

gpdk090_resnsppoly #(.w(2u), .r(5.99959K), .l(29.985u)) (*
integer
library_binding = "gpdk090";
 *)
R1 ( vdd, out_neg, vss );
gpdk090_resnsppoly #(.w(2u), .r(5.99959K), .l(29.985u)) (*
integer
library_binding = "gpdk090";
 *)
R0 ( vdd, out_pos, vss );

gpdk090_nmos2v #(.ps(37.2u), .m(1 * 2), .as(10.8p), .l(2u), .pd(18.6u),
 .ad(5.4p), .w(18u)) (*
integer library_binding = "gpdk090";
integer
passed_mfactor = "m";
 *)
M33 ( net74, Vbias_Poly, vss, vss );
gpdk090_nmos2v #(.ps(11.2u), .m(2 * 2), .as(3p), .l(300n), .pd(5.6u),
.ad(1.5p), .w(5u)) (*
integer library_binding = "gpdk090";
integer
passed_mfactor = "m";
 *)
M31 ( out_pos, INP, net74, vss );
gpdk090_nmos2v #(.ps(11.2u), .m(2 * 2), .as(3p), .l(300n), .pd(5.6u),
.ad(1.5p), .w(5u)) (*
integer library_binding = "gpdk090";
integer
passed_mfactor = "m";
 *)
M32 ( out_neg, INN, net74, vss );

gpdk090_pmos2v #(.ps(3.53u), .m(1 * 1), .as(699f), .l(280.0n), .pd(3.53u),
 .ad(699f), .w(1.165u)) (*
integer library_binding = "gpdk090";

integer passed_mfactor = "m";
 *)
PM12 ( net74, net206, vdd, vdd );

gpdk090_nmoscap2v #(.m(1 * 3), .l(14.1u), .w(4.685u)) (*
integer
library_binding = "gpdk090";
integer passed_mfactor = "m";
 *)
C0 (
vss, net51, vss, vss );
gpdk090_nmoscap2v #(.m(1 * 3), .l(14.1u), .w(4.685u)) (*
integer
library_binding = "gpdk090";
integer passed_mfactor = "m";
 *)
C1 (
vss, net35, vss, vss );

tgate_5X (*
integer library_binding = "ether";
 *)
I5 ( .vss( vss ), .vdd(
vdd ), .in( out_neg ), .EN( filter_on ), .out( net35 ), .ENB(
input_filter_off ) );
tgate_5X (*
integer library_binding = "ether";
 *)
I7 ( .vss( vss ), .vdd(
vdd ), .in( out_pos ), .EN( filter_on ), .out( net51 ), .ENB(
input_filter_off ) );

inv_1X (*
integer library_binding = "ether";
 *)
I8 ( .vss( vss ), .VDD(
vdd ), .in( input_filter_off ), .out( filter_on ) );
inv_1X (*
integer library_binding = "ether";
 *)
I6 ( .vss( vss ), .VDD(
vdd ), .in( siddq ), .out( net206 ) );

endmodule
