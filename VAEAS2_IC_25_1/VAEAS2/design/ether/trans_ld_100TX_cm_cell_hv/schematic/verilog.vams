// Verilog-AMS netlist generated by the AMS netlister, version ICOA5.2.51.500.7.
// Cadence Design Systems, Inc.

`include "disciplines.vams"

module trans_ld_100TX_cm_cell_hv ( a,vbias,b,neg_out,VDD,pos_out,siddq,
switch_vbias,VSS );

input   a;
input   vbias;
input   b;
output   neg_out;
input   VDD;

output   pos_out;
input   siddq;
input   switch_vbias;
input   VSS;

gpdk090_nmos2v #(.ps(53.46u), .m(1 * 20), .as(15.84p), .l(1u), .pd(48.6u),
 .ad(14.4p), .w(48u)) (*
integer library_binding = "gpdk090";
integer
passed_mfactor = "m";
 *)
NM11 ( neg_out, ain, net60, VSS );
gpdk090_nmos2v #(.ps(31.46u), .m(1 * 20), .as(9.24p), .l(280.0n), .pd(28.6u),
 .ad(8.4p), .w(28u)) (*
integer library_binding = "gpdk090";
integer
passed_mfactor = "m";
 *)
NM9 ( net80, siddq, VSS, VSS );
gpdk090_nmos2v #(.ps(31.46u), .m(1 * 20), .as(9.24p), .l(280.0n), .pd(28.6u),
 .ad(8.4p), .w(28u)) (*
integer library_binding = "gpdk090";
integer
passed_mfactor = "m";
 *)
NM10 ( net120, siddq, VSS, VSS );
gpdk090_nmos2v #(.ps(24.8421u), .m(1 * 38), .as(7.26316p), .l(280.0n),
 .pd(23.6u), .ad(6.9p), .w(23u)) (*
integer library_binding
 = "gpdk090";
integer passed_mfactor = "m";
 *)
NM13 ( net60,
switch_vbias, net80, VSS );
gpdk090_nmos2v #(.ps(27.06u), .m(1 * 20), .as(7.92p), .l(1u), .pd(24.6u),
 .ad(7.2p), .w(24u)) (*
integer library_binding = "gpdk090";
integer
passed_mfactor = "m";
 *)
NM14 ( net120, vbias, VSS, VSS );
gpdk090_nmos2v #(.ps(53.46u), .m(1 * 20), .as(15.84p), .l(1u), .pd(48.6u),
 .ad(14.4p), .w(48u)) (*
integer library_binding = "gpdk090";
integer
passed_mfactor = "m";
 *)
NM15 ( pos_out, bin, net91, VSS );
gpdk090_nmos2v #(.ps(53.46u), .m(1 * 20), .as(15.84p), .l(1u), .pd(48.6u),
 .ad(14.4p), .w(48u)) (*
integer library_binding = "gpdk090";
integer
passed_mfactor = "m";
 *)
NM16 ( neg_out, bn, net91, VSS );
gpdk090_nmos2v #(.ps(27.06u), .m(1 * 20), .as(7.92p), .l(1u), .pd(24.6u),
 .ad(7.2p), .w(24u)) (*
integer library_binding = "gpdk090";
integer
passed_mfactor = "m";
 *)
NM17 ( net80, vbias, VSS, VSS );
gpdk090_nmos2v #(.ps(53.46u), .m(1 * 20), .as(15.84p), .l(1u), .pd(48.6u),
 .ad(14.4p), .w(48u)) (*
integer library_binding = "gpdk090";
integer
passed_mfactor = "m";
 *)
NM12 ( pos_out, an, net60, VSS );
gpdk090_nmos2v #(.ps(24.8421u), .m(1 * 38), .as(7.26316p), .l(280.0n),
 .pd(23.6u), .ad(6.9p), .w(23u)) (*
integer library_binding
 = "gpdk090";
integer passed_mfactor = "m";
 *)
NM20 ( net91,
switch_vbias, net120, VSS );

trans_ld_100tx_invequal (*
integer library_binding = "ether";
 *)
I15
 ( .out_inv( bn ), .VDD( VDD ), .in( b ), .out( bin ), .VSS( VSS ) );
trans_ld_100tx_invequal (*
integer library_binding = "ether";
 *)
I17
 ( .out_inv( an ), .VDD( VDD ), .in( a ), .out( ain ), .VSS( VSS ) );

endmodule
