// Verilog-AMS netlist generated by the AMS netlister, version ICOA5.2.51.500.7.
// Cadence Design Systems, Inc.

`include "disciplines.vams"

module trans_ld_tenbt ( avdd,ibias_tenbt,dvdd,ibias_rext2_50u,gnd,
neg_out,tenbt_on,pos_out,dgnd,siddq,tenbt_trans_off,MAN_ENC,
ibias_tenbt_cas );

input   avdd;
input   ibias_tenbt;
input   dvdd;
input
 ibias_rext2_50u;
input   gnd;
output   neg_out;
input   tenbt_on;

output   pos_out;
input   dgnd;
input   siddq;
input
 tenbt_trans_off;
input   MAN_ENC;
input   ibias_tenbt_cas;

parameter td=4E-10;
parameter tfr=4E-10;

gpdk090_nmoscap2v #(.m(20 * 6), .l(12.865u), .w(12.825u)) (*
integer
library_binding = "gpdk090";
integer passed_mfactor = "m";
 *)
C0 (
dgnd, dvdd, dgnd, dgnd );
gpdk090_nmoscap2v #(.m(5 * 5), .l(12.865u), .w(12.825u)) (*
integer
library_binding = "gpdk090";
integer passed_mfactor = "m";
 *)
C1 (
dgnd, dvdd, dgnd, dgnd );

inv_16x_hv (*
integer library_binding = "ether";
integer cds_net_set
[0:1] = { "DVDD","DVSS" };
integer DVDD = "avdd";
integer DVSS
 = "gnd";
 *)
I7 ( .Y( net46 ), .A( tenbt_on ) );

level_shifter_1p0_2p5 (*
integer library_binding = "ether";
 *)
I9 ( .IN(
tenbt_trans_off ), .VDD_1p0( dvdd ), .VDD_2p5( avdd ), .OUT(
tenBT_trans_off_2p5 ), .VSS( gnd ) );
level_shifter_1p0_2p5 (*
integer library_binding = "ether";
 *)
I10 (
.IN( MAN_ENC ), .VDD_1p0( dvdd ), .VDD_2p5( avdd ), .OUT( net060 ), .VSS(
gnd ) );

trans_ld_tenbt_bias (*
integer library_binding = "ether";
 *)
I26 ( .ibias_rext_50u(
ibias_rext2_50u ), .ibias_tenbt( ibias_tenbt ), .tenBT_vbias1( net19 ),
.tenBT_vbias2( net24 ), .tenBT_on( tenbt_on ), .gnd( gnd ), .tenBT_trans_off(
tenBT_trans_off_2p5 ), .vdd( avdd ), .siddq( siddq ), .ibias_tenbt_cas(
ibias_tenbt_cas ) );

trans_ld_tenbt_driver (*
integer library_binding = "ether";
 *)
I25 (
.gnd( gnd ), .pbias1( net19 ), .vdd( avdd ), .neg_out( neg_out ), .pos_out(
pos_out ), .siddq( net46 ), .MAN_ENC( net060 ), .pbias2( net24 ) );

endmodule
