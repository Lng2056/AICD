// Verilog-AMS netlist generated by the AMS netlister, version ICOA5.2.51.500.7.
// Cadence Design Systems, Inc.

`include "disciplines.vams"

module PLL_VCO_CMOSDVR ( INn,VDD,INp,PD,OUT,VSS );

input   INn;
input   VDD;
input   INp;
input   PD;
output   OUT;

input   VSS;

gpdk090_pmos2v #(.ps(15.2u), .m(1 * 1), .as(4.2p), .l(280.0n), .pd(15.2u),
 .ad(4.2p), .w(7u)) (*
integer library_binding = "gpdk090";
integer
passed_mfactor = "m";
 *)
PM10 ( INV1, LVLOUT, VDD, VDD );
gpdk090_pmos2v #(.ps(15.2u), .m(1 * 2), .as(4.2p), .l(280.0n), .pd(7.6u),
 .ad(2.1p), .w(7u)) (*
integer library_binding = "gpdk090";
integer
passed_mfactor = "m";
 *)
PM0 ( OUT, INV1, VDD, VDD );
gpdk090_pmos2v #(.ps(10.2u), .m(1 * 1), .as(2.7p), .l(280.0n), .pd(10.2u),
 .ad(2.7p), .w(4.5u)) (*
integer library_binding = "gpdk090";
integer
passed_mfactor = "m";
 *)
PM3 ( LVLOUT, NOTOUT, VDD, VDD );
gpdk090_pmos2v #(.ps(10.2u), .m(1 * 1), .as(2.7p), .l(280.0n), .pd(10.2u),
 .ad(2.7p), .w(4.5u)) (*
integer library_binding = "gpdk090";
integer
passed_mfactor = "m";
 *)
PM2 ( NOTOUT, LVLOUT, VDD, VDD );

gpdk090_nmos2v #(.ps(8.2u), .m(1 * 2), .as(2.1p), .l(280.0n), .pd(4.1u),
 .ad(1.05p), .w(3.5u)) (*
integer library_binding = "gpdk090";

integer passed_mfactor = "m";
 *)
NM0 ( OUT, INV1, VSS, VSS );
gpdk090_nmos2v #(.ps(8.2u), .m(1 * 1), .as(2.1p), .l(280.0n), .pd(8.2u),
 .ad(2.1p), .w(3.5u)) (*
integer library_binding = "gpdk090";
integer
passed_mfactor = "m";
 *)
NM10 ( INV1, LVLOUT, VSS, VSS );
gpdk090_nmos2v #(.ps(3.2u), .m(1 * 1), .as(600f), .l(280.0n), .pd(3.2u),
 .ad(600f), .w(1u)) (*
integer library_binding = "gpdk090";
integer
passed_mfactor = "m";
 *)
NM12 ( LVLOUT, PD, VSS, VSS );
gpdk090_nmos2v #(.ps(45.2u), .m(1 * 2), .as(13.2p), .l(280.0n), .pd(22.6u),
 .ad(6.6p), .w(22u)) (*
integer library_binding = "gpdk090";
integer
passed_mfactor = "m";
 *)
NM34 ( NOTOUT, INn, VSS, VSS );
gpdk090_nmos2v #(.ps(45.2u), .m(1 * 2), .as(13.2p), .l(280.0n), .pd(22.6u),
 .ad(6.6p), .w(22u)) (*
integer library_binding = "gpdk090";
integer
passed_mfactor = "m";
 *)
NM35 ( LVLOUT, INp, VSS, VSS );

capacitor #(.c(5f)) (*
integer library_binding = "analogLib";
 *)
C1
 ( INV1, VSS );
capacitor #(.c(3f)) (*
integer library_binding = "analogLib";
 *)
C2
 ( NOTOUT, VSS );
capacitor #(.c(5f)) (*
integer library_binding = "analogLib";
 *)
C0
 ( LVLOUT, VSS );

endmodule
