// Verilog-AMS netlist generated by the AMS netlister, version ICOA5.2.51.500.7.
// Cadence Design Systems, Inc.

`include "disciplines.vams"

module analog_test_dec ( ADC_DIS,ADC_TEST,AEQ_DIS,BLW_DIS,FX_DIS,
X10_DIS,TX100_DIS,RCLK125_TST_SEL,SIDDQ,TEST_MODE,BASEFX_DIS,
BASE10X_DIS,BASE100X_DIS );

output   ADC_DIS;
output   ADC_TEST;
output   AEQ_DIS;
output
 BLW_DIS;
output   FX_DIS;
output   X10_DIS;
output   TX100_DIS;

output   RCLK125_TST_SEL;
input   SIDDQ;
input [2:0]  TEST_MODE;

input   BASEFX_DIS;
input   BASE10X_DIS;
input   BASE100X_DIS;

wire [2:0] TEST_MODE;
wire n_56;
wire AEQ_DIS;
wire BLW_DIS;
wire SIDDQ;
wire BASE100X_DIS;
wire n_45;
wire FX_DIS;
wire n_50;
wire n_48;
wire ADC_DIS;
wire n_49;
wire BASE10X_DIS;
wire n_37;
wire n_32;
wire n_42;
wire RCLK125_TST_SEL;
wire n_36;
wire n_46;
wire n_29;
wire BASEFX_DIS;
wire n_51;
wire n_55;
wire X10_DIS;
wire n_23;
wire n_33;
wire ADC_TEST;
wire TX100_DIS;
wire n_52;
wire n_18;
wire n_44;
wire n_30;
wire n_26;

AOI211X1 (*
integer library_binding = "gsclib090";
 *)
i_3 ( .C0( n_50 ),
.A0( BASE100X_DIS ), .A1( BASEFX_DIS ), .B0( TEST_MODE[1] ), .Y( n_52 ) );

NAND2X1 (*
integer library_binding = "gsclib090";
 *)
i_4 ( .Y( n_29 ),
.B( n_52 ), .A( n_23 ) );
NAND2X1 (*
integer library_binding = "gsclib090";
 *)
i_12 ( .Y( n_48 ),
.B( BASE10X_DIS ), .A( BASEFX_DIS ) );
NAND2X1 (*
integer library_binding = "gsclib090";
 *)
i_29 ( .Y( n_23 ),
.B( BASE10X_DIS ), .A( BASE100X_DIS ) );
NAND2X1 (*
integer library_binding = "gsclib090";
 *)
i_79 ( .Y(
X10_DIS ), .B( n_49 ), .A( n_36 ) );
NAND2X1 (*
integer library_binding = "gsclib090";
 *)
i_8 ( .Y( n_33 ),
.B( n_44 ), .A( TEST_MODE[1] ) );
NAND2X1 (*
integer library_binding = "gsclib090";
 *)
i_5 ( .Y( n_55 ),
.B( n_51 ), .A( n_23 ) );
NAND2X1 (*
integer library_binding = "gsclib090";
 *)
i_11 ( .Y( n_46 ),
.B( TEST_MODE[0] ), .A( TEST_MODE[2] ) );
NAND2X1 (*
integer library_binding = "gsclib090";
 *)
i_75 ( .Y(
FX_DIS ), .B( n_32 ), .A( n_49 ) );

AOI31X1 (*
integer library_binding = "gsclib090";
 *)
i_2 ( .A0(
BASEFX_DIS ), .A1( BASE10X_DIS ), .B0( SIDDQ ), .Y( n_49 ), .A2(
BASE100X_DIS ) );

NOR2BX1 (*
integer library_binding = "gsclib090";
 *)
i_6 ( .AN(
TEST_MODE[2] ), .Y( n_44 ), .B( TEST_MODE[0] ) );

NAND2BX1 (*
integer library_binding = "gsclib090";
 *)
i_15 ( .AN(
n_45 ), .Y( n_30 ), .B( TEST_MODE[1] ) );
NAND2BX1 (*
integer library_binding = "gsclib090";
 *)
i_7 ( .AN( n_55 ),
.Y( n_37 ), .B( n_48 ) );
NAND2BX1 (*
integer library_binding = "gsclib090";
 *)
i_9 ( .AN(
TEST_MODE[2] ), .Y( n_45 ), .B( TEST_MODE[0] ) );

NOR2X1 (*
integer library_binding = "gsclib090";
 *)
i_1 ( .Y(
ADC_TEST ), .B( n_45 ), .A( TEST_MODE[1] ) );
NOR2X1 (*
integer library_binding = "gsclib090";
 *)
i_0 ( .Y( n_51 ),
.B( n_50 ), .A( TEST_MODE[1] ) );

OR2X1 (*
integer library_binding = "gsclib090";
 *)
i_24 ( .Y( n_50 ),
.B( TEST_MODE[0] ), .A( TEST_MODE[2] ) );

OAI2BB1X1 (*
integer library_binding = "gsclib090";
 *)
i_20 ( .A0N(
n_46 ), .A1N( TEST_MODE[0] ), .B0( TEST_MODE[1] ), .Y( n_18 ) );
OAI2BB1X1 (*
integer library_binding = "gsclib090";
 *)
i_71 ( .A0N(
n_30 ), .A1N( n_29 ), .B0( n_49 ), .Y( TX100_DIS ) );
OAI2BB1X1 (*
integer library_binding = "gsclib090";
 *)
i_67 ( .A0N(
n_26 ), .A1N( n_29 ), .B0( n_49 ), .Y( AEQ_DIS ) );
OAI2BB1X1 (*
integer library_binding = "gsclib090";
 *)
i_83 ( .A0N(
n_42 ), .A1N( n_55 ), .B0( n_49 ), .Y( BLW_DIS ) );

AO22X1 (*
integer library_binding = "gsclib090";
 *)
i_36 ( .A0( n_48 ),
.A1( n_52 ), .B0( TEST_MODE[1] ), .Y( n_32 ), .B1( n_44 ) );

OAI211X1 (*
integer library_binding = "gsclib090";
 *)
i_14 ( .C0(
n_33 ), .A0( n_44 ), .A1( TEST_MODE[1] ), .B0( n_45 ), .Y( n_26 ) );

OAI31XL (*
integer library_binding = "gsclib090";
 *)
i_63 ( .A0(
RCLK125_TST_SEL ), .A1( n_44 ), .B0( n_49 ), .Y( ADC_DIS ), .A2( n_52 ) );

OAI21XL (*
integer library_binding = "gsclib090";
 *)
i_39 ( .A0(
TEST_MODE[1] ), .A1( n_46 ), .B0( n_37 ), .Y( n_36 ) );
OAI21XL (*
integer library_binding = "gsclib090";
 *)
i_18 ( .A0(
TEST_MODE[0] ), .A1( n_56 ), .B0( TEST_MODE[2] ), .Y( n_42 ) );
OAI21XL (*
integer library_binding = "gsclib090";
 *)
i_21 ( .A0(
TEST_MODE[1] ), .A1( n_45 ), .B0( n_18 ), .Y( RCLK125_TST_SEL ) );

CLKINVX1 (*
integer library_binding = "gsclib090";
 *)
i_92 ( .Y( n_56 ),
.A( TEST_MODE[1] ) );

endmodule
