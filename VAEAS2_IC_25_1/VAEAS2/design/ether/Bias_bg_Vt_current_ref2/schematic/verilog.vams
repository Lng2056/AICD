// Verilog-AMS netlist generated by the AMS netlister, version ICOA5.2.51.500.7.
// Cadence Design Systems, Inc.

`include "disciplines.vams"

module Bias_bg_Vt_current_ref2 ( Iout0,VDD,siddq,VSS,Iout1 );

inout   Iout0;
input   VDD;
input   siddq;
input   VSS;
output
 Iout1;

gpdk090_resnsppoly #(.w(2u), .r(10.6593K), .l(53.285u)) (*
integer
library_binding = "gpdk090";
 *)
RB ( net75, VSS, VSS );

gpdk090_pmos2v #(.ps(3.52u), .m(1 * 1), .as(696f), .l(280.0n), .pd(3.52u),
 .ad(696f), .w(1.16u)) (*
integer library_binding = "gpdk090";

integer passed_mfactor = "m";
 *)
PM9 ( net063, siddq, net93, net93 );
gpdk090_pmos2v #(.ps(3.52u), .m(1 * 1), .as(696f), .l(280.0n), .pd(3.52u),
 .ad(696f), .w(1.16u)) (*
integer library_binding = "gpdk090";

integer passed_mfactor = "m";
 *)
PM10 ( net107, siddq_c, VDD, VDD );
gpdk090_pmos2v #(.ps(11.7u), .m(1 * 1), .as(3.15p), .l(1u), .pd(11.7u),
 .ad(3.15p), .w(5.25u)) (*
integer library_binding = "gpdk090";

integer passed_mfactor = "m";
 *)
PM12 ( Iout0, net107, VDD, VDD );
gpdk090_pmos2v #(.ps(3.2u), .m(1 * 1), .as(600f), .l(1u), .pd(3.2u), .ad(600f),
 .w(1u)) (*
integer library_binding = "gpdk090";
integer
passed_mfactor = "m";
 *)
PM6 ( net93, net93, net96, VDD );
gpdk090_pmos2v #(.ps(3.2u), .m(1 * 1), .as(600f), .l(1u), .pd(3.2u), .ad(600f),
 .w(1u)) (*
integer library_binding = "gpdk090";
integer
passed_mfactor = "m";
 *)
PM5 ( net96, net96, VDD, VDD );
gpdk090_pmos2v #(.ps(11.7u), .m(1 * 1), .as(3.15p), .l(1u), .pd(11.7u),
 .ad(3.15p), .w(5.25u)) (*
integer library_binding = "gpdk090";

integer passed_mfactor = "m";
 *)
PM4 ( Iout1, net107, VDD, VDD );
gpdk090_pmos2v #(.ps(11.4667u), .m(1 * 3), .as(3.2p), .l(1u), .pd(11.4667u),
 .ad(3.2p), .w(8u)) (*
integer library_binding = "gpdk090";
integer
passed_mfactor = "m";
 *)
PM0 ( net063, net107, VDD, VDD );
gpdk090_pmos2v #(.ps(11.4667u), .m(1 * 3), .as(3.2p), .l(1u), .pd(11.4667u),
 .ad(3.2p), .w(8u)) (*
integer library_binding = "gpdk090";
integer
passed_mfactor = "m";
 *)
PM1 ( net107, net107, VDD, VDD );

gpdk090_nmos2v #(.ps(3.52u), .m(1 * 1), .as(696f), .l(280.0n), .pd(3.52u),
 .ad(696f), .w(1.16u)) (*
integer library_binding = "gpdk090";

integer passed_mfactor = "m";
 *)
NM7 ( net063, siddq, VSS, VSS );
gpdk090_nmos2v #(.ps(3.52u), .m(1 * 1), .as(696f), .l(280.0n), .pd(3.52u),
 .ad(696f), .w(1.16u)) (*
integer library_binding = "gpdk090";

integer passed_mfactor = "m";
 *)
NM8 ( Iout0, siddq, VSS, VSS );
gpdk090_nmos2v #(.ps(3.52u), .m(1 * 1), .as(696f), .l(280.0n), .pd(3.52u),
 .ad(696f), .w(1.16u)) (*
integer library_binding = "gpdk090";

integer passed_mfactor = "m";
 *)
NM9 ( Iout1, siddq, VSS, VSS );
gpdk090_nmos2v #(.ps(11.2u), .m(1 * 2), .as(3p), .l(1u), .pd(5.6u), .ad(1.5p),
 .w(5u)) (*
integer library_binding = "gpdk090";
integer
passed_mfactor = "m";
 *)
NM1 ( net107, net063, net75, VSS );
gpdk090_nmos2v #(.ps(6.312u), .m(1 * 5), .as(1.6776p), .l(280.0n), .pd(6.312u),
 .ad(1.6776p), .w(4.66u)) (*
integer library_binding = "gpdk090";

integer passed_mfactor = "m";
 *)
NM_VT ( net063, net75, VSS, VSS );

inv_1x_hv (*
integer library_binding = "ether";
integer cds_net_set
[0:1] = { "DVDD","DVSS" };
integer DVDD = "VDD";
integer DVSS
 = "VSS";
 *)
I6 ( .Y( siddq_c ), .A( siddq ) );

endmodule
