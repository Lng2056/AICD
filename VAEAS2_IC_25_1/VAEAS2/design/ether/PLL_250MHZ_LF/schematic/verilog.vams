// Verilog-AMS netlist generated by the AMS netlister, version ICOA5.2.51.500.7.
// Cadence Design Systems, Inc.

`include "disciplines.vams"

module PLL_250MHZ_LF ( DUMP,TAP,LF,VSS );

input   DUMP;
output   TAP;
input   LF;
input   VSS;

gpdk090_resnsppoly #(.w(2u), .r(18.4983K), .l(92.5014u)) (*
integer
library_binding = "gpdk090";
 *)
R0 ( LF, TAP, VSS );

gpdk090_nmos2v #(.ps(9.9u), .m(1 * 4), .as(2.7p), .l(280.0n), .pd(6.6u),
 .ad(1.8p), .w(6u)) (*
integer library_binding = "gpdk090";
integer
passed_mfactor = "m";
 *)
NM0 ( TAP, DUMP, VSS, VSS );
gpdk090_nmos2v #(.ps(13.2u), .m(1 * 1), .as(3.6p), .l(280.0n), .pd(13.2u),
 .ad(3.6p), .w(6u)) (*
integer library_binding = "gpdk090";
integer
passed_mfactor = "m";
 *)
NM1 ( LF, DUMP, VSS, VSS );

gpdk090_nmoscap2v #(.m(1 * 100), .l(4.07u), .w(13.385u)) (*
integer
library_binding = "gpdk090";
integer passed_mfactor = "m";
 *)
C0 (
VSS, TAP, VSS, VSS );
gpdk090_nmoscap2v #(.m(1 * 10), .l(4.07u), .w(4.055u)) (*
integer
library_binding = "gpdk090";
integer passed_mfactor = "m";
 *)
C1 (
VSS, LF, VSS, VSS );

endmodule
