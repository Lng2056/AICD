// Verilog-AMS netlist generated by the AMS netlister, version ICOA5.2.51.500.7.
// Cadence Design Systems, Inc.

`include "disciplines.vams"

module PI_interp_tap_cell ( VDD,TAP,OUT,VSS );

input   VDD;
input [1:0]  TAP;
output   OUT;
input   VSS;

gpdk090_pmos2v #(.ps(7.5u), .m(1 * 1), .as(1.89p), .l(280.0n), .pd(7.5u),
 .ad(1.89p), .w(3.15u)) (*
integer library_binding = "gpdk090";

integer passed_mfactor = "m";
 *)
PM0 ( net16, TAP[0], VDD, VDD );
gpdk090_pmos2v #(.ps(7.5u), .m(1 * 1), .as(1.89p), .l(280.0n), .pd(7.5u),
 .ad(1.89p), .w(3.15u)) (*
integer library_binding = "gpdk090";

integer passed_mfactor = "m";
 *)
PM1 ( OUT, net16, VDD, VDD );
gpdk090_pmos2v #(.ps(7.5u), .m(1 * 1), .as(1.89p), .l(280.0n), .pd(7.5u),
 .ad(1.89p), .w(3.15u)) (*
integer library_binding = "gpdk090";

integer passed_mfactor = "m";
 *)
PM2 ( net16, TAP[1], VDD, VDD );

gpdk090_nmos2v #(.ps(3.53u), .m(1 * 1), .as(699f), .l(280.0n), .pd(3.53u),
 .ad(699f), .w(1.165u)) (*
integer library_binding = "gpdk090";

integer passed_mfactor = "m";
 *)
NM1 ( net16, TAP[0], VSS, VSS );
gpdk090_nmos2v #(.ps(3.53u), .m(1 * 1), .as(699f), .l(280.0n), .pd(3.53u),
 .ad(699f), .w(1.165u)) (*
integer library_binding = "gpdk090";

integer passed_mfactor = "m";
 *)
NM0 ( OUT, net16, VSS, VSS );
gpdk090_nmos2v #(.ps(3.53u), .m(1 * 1), .as(699f), .l(280.0n), .pd(3.53u),
 .ad(699f), .w(1.165u)) (*
integer library_binding = "gpdk090";

integer passed_mfactor = "m";
 *)
NM2 ( net16, TAP[1], VSS, VSS );

gpdk090_pmoscap2v #(.m(1 * 2), .l(1.5u), .w(4.965u)) (*
integer
library_binding = "gpdk090";
integer passed_mfactor = "m";
 *)
C8 (
VDD, net16, VDD, VDD );

gpdk090_nmoscap2v #(.m(1 * 2), .l(1.5u), .w(5.065u)) (*
integer
library_binding = "gpdk090";
integer passed_mfactor = "m";
 *)
C9 (
VSS, net16, VSS, VSS );

endmodule
