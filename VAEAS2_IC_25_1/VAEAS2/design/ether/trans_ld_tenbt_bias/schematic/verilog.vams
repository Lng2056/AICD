// Verilog-AMS netlist generated by the AMS netlister, version ICOA5.2.51.500.7.
// Cadence Design Systems, Inc.

`include "disciplines.vams"

module trans_ld_tenbt_bias ( ibias_rext_50u,ibias_tenbt,tenBT_vbias1,
tenBT_vbias2,tenBT_on,gnd,tenBT_trans_off,vdd,siddq,ibias_tenbt_cas );

input   ibias_rext_50u;
input   ibias_tenbt;
output   tenBT_vbias1;

output   tenBT_vbias2;
input   tenBT_on;
input   gnd;
input
 tenBT_trans_off;
input   vdd;
input   siddq;
input
 ibias_tenbt_cas;

gpdk090_resnsppoly #(.w(2u), .r(64.5794K), .l(322.883u)) (*
integer
library_binding = "gpdk090";
 *)
R0 ( ibias_tenbt, net96, gnd );

gpdk090_pmos2v #(.ps(21.45u), .m(1 * 24), .as(6.24p), .l(400n), .pd(19.8u),
 .ad(5.76p), .w(19.2u)) (*
integer library_binding = "gpdk090";

integer passed_mfactor = "m";
 *)
PM5 ( tenBT_vbias1, tenBT_vbias2,
net148, net148 );
gpdk090_pmos2v #(.ps(11.4833u), .m(1 * 24), .as(3.25p), .l(1u), .pd(10.6u),
 .ad(3p), .w(10u)) (*
integer library_binding = "gpdk090";
integer
passed_mfactor = "m";
 *)
PM4 ( net148, tenBT_vbias1, vdd, vdd );
gpdk090_pmos2v #(.ps(3.53u), .m(1 * 1), .as(699f), .l(280.0n), .pd(3.53u),
 .ad(699f), .w(1.165u)) (*
integer library_binding = "gpdk090";

integer passed_mfactor = "m";
 *)
PM0 ( tenBT_vbias1, net67, vdd, vdd );
gpdk090_pmos2v #(.ps(3.53u), .m(1 * 1), .as(699f), .l(280.0n), .pd(3.53u),
 .ad(699f), .w(1.165u)) (*
integer library_binding = "gpdk090";

integer passed_mfactor = "m";
 *)
PM16 ( tenBT_vbias2, net67, vdd, vdd );
gpdk090_pmos2v #(.ps(8.408u), .m(2 * 10), .as(8.16p), .l(2u), .pd(360n),
 .ad(7.2p), .w(40u)) (*
integer library_binding = "gpdk090";
integer
passed_mfactor = "m";
 *)
PM19 ( vdd, tenBT_vbias2, vdd, vdd );
gpdk090_pmos2v #(.ps(3.53u), .m(1 * 1), .as(699f), .l(280.0n), .pd(3.53u),
 .ad(699f), .w(1.165u)) (*
integer library_binding = "gpdk090";

integer passed_mfactor = "m";
 *)
PM13 ( net148, net67, vdd, vdd );
gpdk090_pmos2v #(.ps(30.9u), .m(1 * 4), .as(9p), .l(2u), .pd(20.6u), .ad(6p),
 .w(20u)) (*
integer library_binding = "gpdk090";
integer
passed_mfactor = "m";
 *)
PM24 ( vdd, vdd, vdd, vdd );
gpdk090_pmos2v #(.ps(3.53u), .m(1 * 1), .as(699f), .l(280.0n), .pd(3.53u),
 .ad(699f), .w(1.165u)) (*
integer library_binding = "gpdk090";

integer passed_mfactor = "m";
 *)
PM23 ( tenBT_vbias2, net67, vdd, vdd );

gpdk090_nmos2v #(.ps(3.53u), .m(1 * 1), .as(699f), .l(280.0n), .pd(3.53u),
 .ad(699f), .w(1.165u)) (*
integer library_binding = "gpdk090";

integer passed_mfactor = "m";
 *)
NM6 ( ibias_tenbt, \10BT_en , gnd,
gnd );
gpdk090_nmos2v #(.ps(59.0812u), .m(1 * 8), .as(17.4994p), .l(280.0n),
.pd(47.265u), .ad(13.9995p), .w(46.665u)) (*
integer library_binding
 = "gpdk090";
integer passed_mfactor = "m";
 *)
NM26 ( vdd,
tenBT_trans_off, net134, gnd );
gpdk090_nmos2v #(.ps(27.7333u), .m(1 * 24), .as(8.125p), .l(500n), .pd(25.6u),
 .ad(7.5p), .w(25u)) (*
integer library_binding = "gpdk090";
integer
passed_mfactor = "m";
 *)
NM19 ( net134, ibias_tenbt_cas, net108, gnd );
gpdk090_nmos2v #(.ps(59.0812u), .m(1 * 8), .as(17.4994p), .l(280.0n),
.pd(47.265u), .ad(13.9995p), .w(46.665u)) (*
integer library_binding
 = "gpdk090";
integer passed_mfactor = "m";
 *)
NM25 ( tenBT_vbias1,
tenbt_trans_on, net134, gnd );
gpdk090_nmos2v #(.ps(21.2u), .m(1 * 2), .as(6p), .l(2u), .pd(10.6u), .ad(3p),
 .w(10u)) (*
integer library_binding = "gpdk090";
integer
passed_mfactor = "m";
 *)
NM22 ( net152, ibias_rext_50u, gnd, gnd );
gpdk090_nmos2v #(.ps(41.2u), .m(6 * 1), .as(12p), .l(1u), .pd(41.2u),
.ad(12p), .w(20u)) (*
integer library_binding = "gpdk090";
integer
passed_mfactor = "m";
 *)
NM9 ( net108, net96, gnd, gnd );
gpdk090_nmos2v #(.ps(3.53u), .m(1 * 1), .as(699f), .l(280.0n), .pd(3.53u),
 .ad(699f), .w(1.165u)) (*
integer library_binding = "gpdk090";

integer passed_mfactor = "m";
 *)
NM38 ( ibias_tenbt_cas, \10BT_en ,
gnd, gnd );
gpdk090_nmos2v #(.ps(94.53u), .m(1 * 2), .as(27.999p), .l(280.0n), .pd(47.265u),
 .ad(13.9995p), .w(46.665u)) (*
integer library_binding = "gpdk090";

integer passed_mfactor = "m";
 *)
NM27 ( vdd, tenbt_trans_on, net152,
gnd );
gpdk090_nmos2v #(.ps(94.53u), .m(1 * 2), .as(27.999p), .l(280.0n), .pd(47.265u),
 .ad(13.9995p), .w(46.665u)) (*
integer library_binding = "gpdk090";

integer passed_mfactor = "m";
 *)
NM28 ( tenBT_vbias1, tenBT_trans_off,
net152, gnd );
gpdk090_nmos2v #(.ps(21.2u), .m(1 * 1), .as(6p), .l(2u), .pd(21.2u), .ad(6p),
 .w(10u)) (*
integer library_binding = "gpdk090";
integer
passed_mfactor = "m";
 *)
NM21 ( ibias_rext_50u, ibias_rext_50u, gnd,
gnd );
gpdk090_nmos2v #(.ps(38.4u), .m(1 * 4), .as(11.25p), .l(500n), .pd(25.6u),
 .ad(7.5p), .w(25u)) (*
integer library_binding = "gpdk090";
integer
passed_mfactor = "m";
 *)
NM42 ( gnd, gnd, gnd, gnd );
gpdk090_nmos2v #(.ps(3.53u), .m(1 * 1), .as(699f), .l(280.0n), .pd(3.53u),
 .ad(699f), .w(1.165u)) (*
integer library_binding = "gpdk090";

integer passed_mfactor = "m";
 *)
NM39 ( ibias_rext_50u, \10BT_en ,
gnd, gnd );
gpdk090_nmos2v #(.ps(41.2u), .m(1 * 1), .as(12p), .l(2u), .pd(41.2u),
.ad(12p), .w(20u)) (*
integer library_binding = "gpdk090";
integer
passed_mfactor = "m";
 *)
NM40 ( gnd, gnd, gnd, gnd );
gpdk090_nmos2v #(.ps(21.9733u), .m(1 * 15), .as(6.4p), .l(760.0n), .pd(21.9733u),
 .ad(6.4p), .w(20u)) (*
integer library_binding = "gpdk090";
integer
passed_mfactor = "m";
 *)
NM44 ( gnd, ibias_tenbt_cas, gnd, gnd );
gpdk090_nmos2v #(.ps(41.2u), .m(6 * 1), .as(12p), .l(1u), .pd(41.2u),
.ad(12p), .w(20u)) (*
integer library_binding = "gpdk090";
integer
passed_mfactor = "m";
 *)
NM5 ( tenBT_vbias2, net96, gnd, gnd );
gpdk090_nmos2v #(.ps(32u), .m(1 * 8), .as(9.375p), .l(500n), .pd(25.6u),
 .ad(7.5p), .w(25u)) (*
integer library_binding = "gpdk090";
integer
passed_mfactor = "m";
 *)
NM23 ( ibias_tenbt, ibias_tenbt_cas, net133,
gnd );
gpdk090_nmos2v #(.ps(41.2u), .m(2 * 1), .as(12p), .l(1u), .pd(41.2u),
.ad(12p), .w(20u)) (*
integer library_binding = "gpdk090";
integer
passed_mfactor = "m";
 *)
NM10 ( net133, ibias_tenbt, gnd, gnd );

gpdk090_nmoscap2v #(.m(31 * 1), .l(5u), .w(4.985u)) (*
integer
library_binding = "gpdk090";
integer passed_mfactor = "m";
 *)
C0 (
gnd, net96, gnd, gnd );

nor2_1x_hv (*
integer library_binding = "ether";
integer cds_net_set
[0:1] = { "DVDD","DVSS" };
integer DVDD = "vdd";
integer DVSS
 = "gnd";
 *)
I20 ( .Y( net67 ), .B( siddq ), .A( net090 ) );

inv_1x_hv (*
integer library_binding = "ether";
integer cds_net_set
[0:1] = { "DVDD","DVSS" };
integer DVDD = "vdd";
integer DVSS
 = "gnd";
 *)
I32 ( .Y( \10BT_en  ), .A( net67 ) );
inv_1x_hv (*
integer library_binding = "ether";
integer cds_net_set
[0:1] = { "DVDD","DVSS" };
integer DVDD = "vdd";
integer DVSS
 = "gnd";
 *)
I36 ( .Y( net090 ), .A( tenBT_on ) );
inv_1x_hv (*
integer library_binding = "ether";
integer cds_net_set
[0:1] = { "DVSS","DVDD" };
integer DVSS = "gnd";
integer DVDD
 = "vdd";
 *)
I35 ( .Y( tenbt_trans_on ), .A( tenBT_trans_off ) );

trans_ld_tenbt_bias_cascode (*
integer library_binding = "ether";
 *)

I25 ( .S( gnd ), .D( ibias_tenbt_cas ), .G( ibias_tenbt_cas ), .B( gnd ) );

trans_ld_tenbt_bias_pcascode (*
integer library_binding = "ether";

 *)
I26 ( .S( vdd ), .D( tenBT_vbias2 ), .G( tenBT_vbias2 ), .B( vdd ) );

endmodule
