// Verilog-AMS netlist generated by the AMS netlister, version ICOA5.2.51.500.7.
// Cadence Design Systems, Inc.

`include "disciplines.vams"

module trans_ld_100tx_bias_cascode ( S,D,G,B );

inout   S;
inout   D;
inout   G;
inout   B;

gpdk090_nmos2v #(.ps(10.53u), .m(1 * 1), .as(2.799p), .l(280.0n), .pd(10.53u),
 .ad(2.799p), .w(4.665u)) (*
integer library_binding = "gpdk090";

integer passed_mfactor = "m";
 *)
NM41 ( net63, G, net59, B );
gpdk090_nmos2v #(.ps(21.2u), .m(1 * 1), .as(6p), .l(1u), .pd(21.2u), .ad(6p),
 .w(10u)) (*
integer library_binding = "gpdk090";
integer
passed_mfactor = "m";
 *)
NM0 ( net67, G, S, B );
gpdk090_nmos2v #(.ps(10.53u), .m(1 * 1), .as(2.799p), .l(280.0n), .pd(10.53u),
 .ad(2.799p), .w(4.665u)) (*
integer library_binding = "gpdk090";

integer passed_mfactor = "m";
 *)
NM40 ( D, G, net63, B );
gpdk090_nmos2v #(.ps(21.2u), .m(1 * 1), .as(6p), .l(1u), .pd(21.2u), .ad(6p),
 .w(10u)) (*
integer library_binding = "gpdk090";
integer
passed_mfactor = "m";
 *)
NM42 ( net59, G, net67, B );

endmodule
