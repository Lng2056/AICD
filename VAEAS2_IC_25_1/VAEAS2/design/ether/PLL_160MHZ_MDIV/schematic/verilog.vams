// Verilog-AMS netlist generated by the AMS netlister, version ICOA5.2.51.500.7.
// Cadence Design Systems, Inc.

`include "disciplines.vams"

module PLL_160MHZ_MDIV ( CLK160,CLKFB,CLKVCO,VDD,VSS );

output   CLK160;
output   CLKFB;
input   CLKVCO;
input   VDD;
input
 VSS;

wire [6:0] qb;
wire [6:0] q;
wire [6:1] d;
wire [6:1] ck;

parameter Threshold=0;
parameter Vpwr=0;
parameter Tprop=0;
parameter Ttrans=0;

or4_1x_hv (*
integer library_binding = "ether";
integer cds_net_set
[0:1] = { "DVSS","DVDD" };
integer DVSS = "VSS";
integer DVDD
 = "VDD";
 *)
I48 ( .D( tieLo ), .C( q[5] ), .Y( net64 ), .B( q[4] ),
.A( q[3] ) );

nor3_2x_hv (*
integer library_binding = "ether";
integer cds_net_set
[0:1] = { "DVDD","DVSS" };
integer DVDD = "VDD";
integer DVSS
 = "VSS";
 *)
I54 ( .C( net64 ), .Y( cntLt2 ), .B( q[2] ), .A( q[1] ) );

and2_1x_hv (*
integer library_binding = "ether";
integer cds_net_set
[0:1] = { "DVDD","DVSS" };
integer DVDD = "VDD";
integer DVSS
 = "VSS";
 *)
I46 ( .Y( cntZero ), .B( qb[0] ), .A( cntLt2 ) );

clkbuf_4x_hv (*
integer library_binding = "ether";
integer cds_net_set
[0:1] = { "DVDD","DVSS" };
integer DVDD = "VDD";
integer DVSS
 = "VSS";
 *)
I11 ( .Y( CLK160 ), .A( q[0] ) );
clkbuf_4x_hv (*
integer library_binding = "ether";
integer cds_net_set
[0:1] = { "DVDD","DVSS" };
integer DVDD = "VDD";
integer DVSS
 = "VSS";
 *)
I7 ( .Y( CLKFB ), .A( divClk ) );

clkbuf_2x_hv (*
integer library_binding = "ether";
integer cds_net_set
[0:1] = { "DVSS","DVDD" };
integer DVSS = "VSS";
integer DVDD
 = "VDD";
 *)
I10 ( .Y( clk ), .A( CLKVCO ) );

tielo_hv (*
integer library_binding = "ether";
integer cds_net_set
[0:1] = { "DVDD","DVSS" };
integer DVDD = "VDD";
integer DVSS
 = "VSS";
 *)
I50 ( .Y( tieLo ) );

nand2_1x_hv (*
integer library_binding = "ether";
integer cds_net_set
[0:1] = { "DVSS","DVDD" };
integer DVSS = "VSS";
integer DVDD
 = "VDD";
 *)
I40 ( .Y( ck[3] ), .B( qb[2] ), .A( load ) );
nand2_1x_hv (*
integer library_binding = "ether";
integer cds_net_set
[0:1] = { "DVSS","DVDD" };
integer DVSS = "VSS";
integer DVDD
 = "VDD";
 *)
I43 ( .Y( ck[4] ), .B( qb[3] ), .A( load ) );
nand2_1x_hv (*
integer library_binding = "ether";
integer cds_net_set
[0:1] = { "DVSS","DVDD" };
integer DVSS = "VSS";
integer DVDD
 = "VDD";
 *)
I37 ( .Y( ck[2] ), .B( qb[1] ), .A( load ) );
nand2_1x_hv (*
integer library_binding = "ether";
integer cds_net_set
[0:1] = { "DVSS","DVDD" };
integer DVSS = "VSS";
integer DVDD
 = "VDD";
 *)
I20 ( .Y( ck[1] ), .B( qb[0] ), .A( load ) );
nand2_1x_hv (*
integer library_binding = "ether";
integer cds_net_set
[0:1] = { "DVDD","DVSS" };
integer DVDD = "VDD";
integer DVSS
 = "VSS";
 *)
I51 ( .Y( ck[5] ), .B( qb[4] ), .A( load ) );
nand2_1x_hv (*
integer library_binding = "ether";
integer cds_net_set
[0:1] = { "DVDD","DVSS" };
integer DVDD = "VDD";
integer DVSS
 = "VSS";
 *)
I57 ( .Y( ck[6] ), .B( qb[5] ), .A( load ) );

dff_1x_hv (*
integer library_binding = "ether";
integer cds_net_set
[0:1] = { "DVSS","DVDD" };
integer DVSS = "VSS";
integer DVDD
 = "VDD";
 *)
I39 ( .QN( qb[3] ), .D( d[3] ), .CK( ck[3] ), .Q( q[3] ) );
dff_1x_hv (*
integer library_binding = "ether";
integer cds_net_set
[0:1] = { "DVSS","DVDD" };
integer DVSS = "VSS";
integer DVDD
 = "VDD";
 *)
I44 ( .QN( qb[4] ), .D( d[4] ), .CK( ck[4] ), .Q( q[4] ) );
dff_1x_hv (*
integer library_binding = "ether";
integer cds_net_set
[0:1] = { "DVSS","DVDD" };
integer DVSS = "VSS";
integer DVDD
 = "VDD";
 *)
I33 ( .QN( qb[0] ), .D( qb[0] ), .CK( clk ), .Q( q[0] ) );
dff_1x_hv (*
integer library_binding = "ether";
integer cds_net_set
[0:1] = { "DVSS","DVDD" };
integer DVSS = "VSS";
integer DVDD
 = "VDD";
 *)
I38 ( .QN( qb[2] ), .D( d[2] ), .CK( ck[2] ), .Q( q[2] ) );
dff_1x_hv (*
integer library_binding = "ether";
integer cds_net_set
[0:1] = { "DVSS","DVDD" };
integer DVSS = "VSS";
integer DVDD
 = "VDD";
 *)
I17 ( .QN( qb[1] ), .D( d[1] ), .CK( ck[1] ), .Q( q[1] ) );
dff_1x_hv (*
integer library_binding = "ether";
integer cds_net_set
[0:1] = { "DVSS","DVDD" };
integer DVSS = "VSS";
integer DVDD
 = "VDD";
 *)
I34 ( .QN( load ), .D( cntZero ), .CK( clk ), .Q( divClk ) );
dff_1x_hv (*
integer library_binding = "ether";
integer cds_net_set
[0:1] = { "DVDD","DVSS" };
integer DVDD = "VDD";
integer DVSS
 = "VSS";
 *)
I53 ( .QN( qb[5] ), .D( d[5] ), .CK( ck[5] ), .Q( q[5] ) );
dff_1x_hv (*
integer library_binding = "ether";
integer cds_net_set
[0:1] = { "DVSS","DVDD" };
integer DVSS = "VSS";
integer DVDD
 = "VDD";
 *)
I59 ( .QN( qb[6] ), .D( d[6] ), .CK( ck[6] ), .Q( q[6] ) );

mux2inv_1x_hv (*
integer library_binding = "ether";
integer
cds_net_set[0:1] = { "DVDD","DVSS" };
integer DVDD = "VDD";
integer
DVSS = "VSS";
 *)
I36 ( .S0( cntLt2 ), .Y( d[2] ), .B( tieLo ), .A(
q[2] ) );
mux2inv_1x_hv (*
integer library_binding = "ether";
integer
cds_net_set[0:1] = { "DVDD","DVSS" };
integer DVDD = "VDD";
integer
DVSS = "VSS";
 *)
I42 ( .S0( cntLt2 ), .Y( d[4] ), .B( tieLo ), .A(
q[4] ) );
mux2inv_1x_hv (*
integer library_binding = "ether";
integer
cds_net_set[0:1] = { "DVDD","DVSS" };
integer DVDD = "VDD";
integer
DVSS = "VSS";
 *)
I41 ( .S0( cntLt2 ), .Y( d[3] ), .B( tieLo ), .A(
q[3] ) );
mux2inv_1x_hv (*
integer library_binding = "ether";
integer
cds_net_set[0:1] = { "DVDD","DVSS" };
integer DVDD = "VDD";
integer
DVSS = "VSS";
 *)
I52 ( .S0( cntLt2 ), .Y( d[5] ), .B( tieLo ), .A(
q[5] ) );
mux2inv_1x_hv (*
integer library_binding = "ether";
integer
cds_net_set[0:1] = { "DVDD","DVSS" };
integer DVDD = "VDD";
integer
DVSS = "VSS";
 *)
I58 ( .S0( cntLt2 ), .Y( d[6] ), .B( tieHi ), .A(
q[6] ) );
mux2inv_1x_hv (*
integer library_binding = "ether";
integer
cds_net_set[0:1] = { "DVDD","DVSS" };
integer DVDD = "VDD";
integer
DVSS = "VSS";
 *)
I35 ( .S0( cntLt2 ), .Y( d[1] ), .B( tieLo ), .A(
q[1] ) );

tiehi_hv (*
integer library_binding = "ether";
integer cds_net_set
[0:1] = { "DVSS","DVDD" };
integer DVSS = "VSS";
integer DVDD
 = "VDD";
 *)
I49 ( .Y( tieHi ) );

endmodule
