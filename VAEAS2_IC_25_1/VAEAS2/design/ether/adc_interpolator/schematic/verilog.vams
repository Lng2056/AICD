// Verilog-AMS netlist generated by the AMS netlister, version ICOA5.2.51.500.7.
// Cadence Design Systems, Inc.

`include "disciplines.vams"

module adc_interpolator ( outn,outp,VDD,VSS,bias,inn,inp,refn,refp );

output   outn;
output   outp;
input   VDD;
input   VSS;
input
 bias;
input   inn;
input   inp;
input   refn;
input   refp;

parameter ibias=0.0004;
parameter rint=1600;

gpdk090_resnsppoly #(.w(2u), .r(1.59953K), .l(7.98429u)) (*
integer
library_binding = "gpdk090";
 *)
R2 ( VDD, outn, VDD );
gpdk090_resnsppoly #(.w(2u), .r(1.59953K), .l(7.98429u)) (*
integer
library_binding = "gpdk090";
 *)
R3 ( VDD, outp, VDD );

gpdk090_nmos2v #(.ps(41.2u), .m(4 * 2), .as(12p), .l(2u), .pd(20.6u),
.ad(6p), .w(20u)) (*
integer library_binding = "gpdk090";
integer
passed_mfactor = "m";
 *)
NM5 ( net30, bias, VSS, VSS );
gpdk090_nmos2v #(.ps(30.9u), .m(2 * 4), .as(9p), .l(280.0n), .pd(20.6u),
 .ad(6p), .w(20u)) (*
integer library_binding = "gpdk090";
integer
passed_mfactor = "m";
 *)
NM4 ( outp, refp, net30, VSS );
gpdk090_nmos2v #(.ps(30.9u), .m(2 * 4), .as(9p), .l(280.0n), .pd(20.6u),
 .ad(6p), .w(20u)) (*
integer library_binding = "gpdk090";
integer
passed_mfactor = "m";
 *)
NM3 ( outn, inp, net30, VSS );
gpdk090_nmos2v #(.ps(30.9u), .m(2 * 4), .as(9p), .l(280.0n), .pd(20.6u),
 .ad(6p), .w(20u)) (*
integer library_binding = "gpdk090";
integer
passed_mfactor = "m";
 *)
NM1 ( outn, refn, net38, VSS );
gpdk090_nmos2v #(.ps(30.9u), .m(2 * 4), .as(9p), .l(280.0n), .pd(20.6u),
 .ad(6p), .w(20u)) (*
integer library_binding = "gpdk090";
integer
passed_mfactor = "m";
 *)
NM0 ( outp, inn, net38, VSS );
gpdk090_nmos2v #(.ps(41.2u), .m(4 * 2), .as(12p), .l(2u), .pd(20.6u),
.ad(6p), .w(20u)) (*
integer library_binding = "gpdk090";
integer
passed_mfactor = "m";
 *)
NM2 ( net38, bias, VSS, VSS );

capacitor #(.c(100f)) (*
integer library_binding = "analogLib";
 *)
C0
 ( outn, VSS );
capacitor #(.c(100f)) (*
integer library_binding = "analogLib";
 *)
C1
 ( outp, VSS );
capacitor #(.c(50f)) (*
integer library_binding = "analogLib";
 *)
C5
 ( inn, VSS );
capacitor #(.c(130f)) (*
integer library_binding = "analogLib";
 *)
C4
 ( refn, VSS );
capacitor #(.c(50f)) (*
integer library_binding = "analogLib";
 *)
C2
 ( inp, VSS );
capacitor #(.c(130f)) (*
integer library_binding = "analogLib";
 *)
C3
 ( refp, VSS );
capacitor #(.c(50f)) (*
integer library_binding = "analogLib";
 *)
C7
 ( net30, VSS );
capacitor #(.c(50f)) (*
integer library_binding = "analogLib";
 *)
C6
 ( net38, VSS );

endmodule
