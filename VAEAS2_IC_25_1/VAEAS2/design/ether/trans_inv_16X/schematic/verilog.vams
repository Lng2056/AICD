// Verilog-AMS netlist generated by the AMS netlister, version ICOA5.2.51.500.7.
// Cadence Design Systems, Inc.

`include "disciplines.vams"

module trans_inv_16X ( Vgnd,in,out,Vpwr );

input   Vgnd;
input   in;
output   out;
input   Vpwr;

parameter td=0;
parameter tr=0;
parameter tf=0;

gpdk090_nmos2v #(.ps(4.05u), .m(1 * 4), .as(945f), .l(280.0n), .pd(2.7u),
 .ad(630f), .w(2.1u)) (*
integer library_binding = "gpdk090";
integer
passed_mfactor = "m";
 *)
NM0 ( out, in, Vgnd, Vgnd );

gpdk090_pmos2v #(.ps(9.3u), .m(1 * 4), .as(2.52p), .l(280.0n), .pd(6.2u),
 .ad(1.68p), .w(5.6u)) (*
integer library_binding = "gpdk090";

integer passed_mfactor = "m";
 *)
PM0 ( out, in, Vpwr, Vpwr );

endmodule
