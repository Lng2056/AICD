// Verilog-AMS netlist generated by the AMS netlister, version ICOA5.2.51.500.7.
// Cadence Design Systems, Inc.

`include "disciplines.vams"

module adcflash_comparator_actr ( outm,outp,SIDDQ,VDD,VSS,inn,inp,ph1,
ph2b,refn,refp,vbias );

output   outm;
output   outp;
input   SIDDQ;
input   VDD;
input
 VSS;
input   inn;
input   inp;
input   ph1;
input   ph2b;
input
 refn;
input   refp;
input   vbias;

gpdk090_resnsppoly #(.w(4u), .r(999.863), .l(9.985u)) (*
integer
library_binding = "gpdk090";
 *)
R2 ( VDD, ampm, VDD );
gpdk090_resnsppoly #(.w(4u), .r(999.863), .l(9.985u)) (*
integer
library_binding = "gpdk090";
 *)
R3 ( VDD, ampp, VDD );

gpdk090_nmos2v #(.ps(19.87u), .m(1 * 1), .as(5.601p), .l(280.0n), .pd(19.87u),
 .ad(5.601p), .w(9.335u)) (*
integer library_binding = "gpdk090";

integer passed_mfactor = "m";
 *)
NM2 ( b0, a0, net125, VSS );
gpdk090_nmos2v #(.ps(21.2u), .m(3 * 1), .as(6p), .l(1u), .pd(21.2u), .ad(6p),
 .w(10u)) (*
integer library_binding = "gpdk090";
integer
passed_mfactor = "m";
 *)
NM12 ( net81, vbias, VSS, VSS );
gpdk090_nmos2v #(.ps(21.2u), .m(2 * 2), .as(6p), .l(300n), .pd(10.6u),
 .ad(3p), .w(10u)) (*
integer library_binding = "gpdk090";
integer
passed_mfactor = "m";
 *)
NM6 ( ampm, refn, net81, VSS );
gpdk090_nmos2v #(.ps(21.2u), .m(2 * 2), .as(6p), .l(300n), .pd(10.6u),
 .ad(3p), .w(10u)) (*
integer library_binding = "gpdk090";
integer
passed_mfactor = "m";
 *)
NM7 ( ampp, inn, net81, VSS );
gpdk090_nmos2v #(.ps(10.32u), .m(1 * 5), .as(2.88p), .l(1u), .pd(10.32u),
 .ad(2.88p), .w(8u)) (*
integer library_binding = "gpdk090";
integer
passed_mfactor = "m";
 *)
NM11 ( VSS, VDD, VSS, VSS );
gpdk090_nmos2v #(.ps(21.2u), .m(3 * 1), .as(6p), .l(1u), .pd(21.2u), .ad(6p),
 .w(10u)) (*
integer library_binding = "gpdk090";
integer
passed_mfactor = "m";
 *)
NM5 ( net30, vbias, VSS, VSS );
gpdk090_nmos2v #(.ps(21.2u), .m(2 * 2), .as(6p), .l(300n), .pd(10.6u),
 .ad(3p), .w(10u)) (*
integer library_binding = "gpdk090";
integer
passed_mfactor = "m";
 *)
NM4 ( ampp, refp, net30, VSS );
gpdk090_nmos2v #(.ps(21.2u), .m(2 * 2), .as(6p), .l(300n), .pd(10.6u),
 .ad(3p), .w(10u)) (*
integer library_binding = "gpdk090";
integer
passed_mfactor = "m";
 *)
NM3 ( ampm, inp, net30, VSS );
gpdk090_nmos2v #(.ps(21.2u), .m(1 * 1), .as(6p), .l(280.0n), .pd(21.2u),
 .ad(6p), .w(10u)) (*
integer library_binding = "gpdk090";
integer
passed_mfactor = "m";
 *)
NM1 ( net125, ph1, VSS, VSS );
gpdk090_nmos2v #(.ps(19.87u), .m(1 * 1), .as(5.601p), .l(280.0n), .pd(19.87u),
 .ad(5.601p), .w(9.335u)) (*
integer library_binding = "gpdk090";

integer passed_mfactor = "m";
 *)
NM0 ( a0, b0, net125, VSS );

gpdk090_pmos2v #(.ps(21.2u), .m(1 * 1), .as(6p), .l(280.0n), .pd(21.2u),
 .ad(6p), .w(10u)) (*
integer library_binding = "gpdk090";
integer
passed_mfactor = "m";
 *)
PM11 ( a0, ph2b, ampm, VDD );
gpdk090_pmos2v #(.ps(21.2u), .m(1 * 1), .as(6p), .l(280.0n), .pd(21.2u),
 .ad(6p), .w(10u)) (*
integer library_binding = "gpdk090";
integer
passed_mfactor = "m";
 *)
PM3 ( b0, ph2b, ampp, VDD );
gpdk090_pmos2v #(.ps(19.87u), .m(1 * 2), .as(5.601p), .l(280.0n), .pd(9.935u),
 .ad(2.8005p), .w(9.335u)) (*
integer library_binding = "gpdk090";

integer passed_mfactor = "m";
 *)
PM2 ( b0, a0, VDD, VDD );
gpdk090_pmos2v #(.ps(19.87u), .m(1 * 2), .as(5.601p), .l(280.0n), .pd(9.935u),
 .ad(2.8005p), .w(9.335u)) (*
integer library_binding = "gpdk090";

integer passed_mfactor = "m";
 *)
PM0 ( a0, b0, VDD, VDD );

clkbuf_2x_hv (*
integer library_binding = "ether";
integer cds_net_set
[0:1] = { "DVDD","DVSS" };
integer DVDD = "VDD";
integer DVSS
 = "VSS";
 *)
I16 ( .Y( outp ), .A( net088 ) );
clkbuf_2x_hv (*
integer library_binding = "ether";
integer cds_net_set
[0:1] = { "DVDD","DVSS" };
integer DVDD = "VDD";
integer DVSS
 = "VSS";
 *)
I17 ( .Y( outm ), .A( net085 ) );

nand2_2x_hv (*
integer library_binding = "ether";
integer cds_net_set
[0:1] = { "DVSS","DVDD" };
integer DVSS = "VSS";
integer DVDD
 = "VDD";
 *)
I13 ( .Y( net085 ), .B( b0 ), .A( net088 ) );
nand2_2x_hv (*
integer library_binding = "ether";
integer cds_net_set
[0:1] = { "DVSS","DVDD" };
integer DVSS = "VSS";
integer DVDD
 = "VDD";
 *)
I12 ( .Y( net088 ), .B( a0 ), .A( net085 ) );

capacitor #(.c(30f)) (*
integer library_binding = "analogLib";
 *)
C7
 ( refp, VSS );
capacitor #(.c(20f)) (*
integer library_binding = "analogLib";
 *)
C2
 ( ampm, VSS );
capacitor #(.c(30f)) (*
integer library_binding = "analogLib";
 *)
C5
 ( inn, VSS );
capacitor #(.c(30f)) (*
integer library_binding = "analogLib";
 *)
C4
 ( inp, VSS );
capacitor #(.c(30f)) (*
integer library_binding = "analogLib";
 *)
C6
 ( refn, VSS );
capacitor #(.c(15f)) (*
integer library_binding = "analogLib";
 *)
C0
 ( a0, VSS );
capacitor #(.c(15f)) (*
integer library_binding = "analogLib";
 *)
C1
 ( b0, VSS );
capacitor #(.c(20f)) (*
integer library_binding = "analogLib";
 *)
C3
 ( ampp, VSS );

endmodule
