// Verilog-AMS netlist generated by the AMS netlister, version ICOA5.2.51.500.7.
// Cadence Design Systems, Inc.

`include "disciplines.vams"

module PLL_ARST ( COMP,LFTAP,VDD,PD,VSS,Ibias );

output   COMP;
input   LFTAP;
input   VDD;
input   PD;
input   VSS;

input   Ibias;

wire [1:50] tap;

gpdk090_resnsppoly #(.w(2u), .r(2.9993K), .l(14.985u)) (*
integer
library_binding = "gpdk090";
 *)
R1_4 ( VDD, net0168, VDD );
gpdk090_resnsppoly #(.w(2u), .r(2.9993K), .l(14.985u)) (*
integer
library_binding = "gpdk090";
 *)
R2_4 ( VDD, net0171, VDD );
gpdk090_resnsppoly #(.w(2u), .r(2.9993K), .l(14.985u)) (*
integer
library_binding = "gpdk090";
 *)
R1_2 ( net0165, net0177, VDD );
gpdk090_resnsppoly #(.w(2u), .r(2.9993K), .l(14.985u)) (*
integer
library_binding = "gpdk090";
 *)
R2_2 ( net0162, net0180, VDD );
gpdk090_resnsppoly #(.w(2u), .r(2.00051K), .l(9.99u)) (*
integer
library_binding = "gpdk090";
integer elaboration_binding
 = "R0[10:50]";
 *)
R0_10 ( tap[9], tap[10], VDD ),
  R0_11 ( tap[10], tap[11], VDD ),
  R0_12 ( tap[11], tap[12], VDD ),
  R0_13 ( tap[12], tap[13], VDD ),
  R0_14 ( tap[13], tap[14], VDD ),
  R0_15 ( tap[14], tap[15], VDD ),
  R0_16 ( tap[15], tap[16], VDD ),
  R0_17 ( tap[16], tap[17], VDD ),
  R0_18 ( tap[17], tap[18], VDD ),
  R0_19 ( tap[18], tap[19], VDD ),
  R0_20 ( tap[19], tap[20], VDD ),
  R0_21 ( tap[20], tap[21], VDD ),
  R0_22 ( tap[21], tap[22], VDD ),
  R0_23 ( tap[22], tap[23], VDD ),
  R0_24 ( tap[23], tap[24], VDD ),
  R0_25 ( tap[24], tap[25], VDD ),
  R0_26 ( tap[25], tap[26], VDD ),
  R0_27 ( tap[26], tap[27], VDD ),
  R0_28 ( tap[27], tap[28], VDD ),
  R0_29 ( tap[28], tap[29], VDD ),
  R0_30 ( tap[29], tap[30], VDD ),
  R0_31 ( tap[30], tap[31], VDD ),
  R0_32 ( tap[31], tap[32], VDD ),
  R0_33 ( tap[32], tap[33], VDD ),
  R0_34 ( tap[33], tap[34], VDD ),
  R0_35 ( tap[34], tap[35], VDD ),
  R0_36 ( tap[35], tap[36], VDD ),
  R0_37 ( tap[36], tap[37], VDD ),
  R0_38 ( tap[37], tap[38], VDD ),
  R0_39 ( tap[38], tap[39], VDD ),
  R0_40 ( tap[39], tap[40], VDD ),
  R0_41 ( tap[40], tap[41], VDD ),
  R0_42 ( tap[41], tap[42], VDD ),
  R0_43 ( tap[42], tap[43], VDD ),
  R0_44 ( tap[43], tap[44], VDD ),
  R0_45 ( tap[44], tap[45], VDD ),
  R0_46 ( tap[45], tap[46], VDD ),
  R0_47 ( tap[46], tap[47], VDD ),
  R0_48 ( tap[47], tap[48], VDD ),
  R0_49 ( tap[48], tap[49], VDD ),
  R0_50 ( tap[49], tap[50], VDD );
gpdk090_resnsppoly #(.w(2u), .r(2.9993K), .l(14.985u)) (*
integer
library_binding = "gpdk090";
 *)
R1_3 ( net0168, net0165, VDD );
gpdk090_resnsppoly #(.w(2u), .r(2.9993K), .l(14.985u)) (*
integer
library_binding = "gpdk090";
 *)
R2_3 ( net0171, net0162, VDD );
gpdk090_resnsppoly #(.w(2u), .r(2.00051K), .l(9.99u)) (*
integer
library_binding = "gpdk090";
integer elaboration_binding = "R0[1:1]";

 *)
R0_1 ( VDD, tap[1], VDD );
gpdk090_resnsppoly #(.w(2u), .r(2.9993K), .l(14.985u)) (*
integer
library_binding = "gpdk090";
 *)
R1_d ( VDD, VDD, VDD );
gpdk090_resnsppoly #(.w(2u), .r(2.00051K), .l(9.99u)) (*
integer
library_binding = "gpdk090";
integer elaboration_binding
 = "R0_d[1:4]";
 *)
R0_d_1 ( VDD, VDD, VDD ),
  R0_d_2 ( VDD, VDD, VDD ),
  R0_d_3 ( VDD, VDD, VDD ),
  R0_d_4 ( VDD, VDD, VDD );
gpdk090_resnsppoly #(.w(2u), .r(2.9993K), .l(14.985u)) (*
integer
library_binding = "gpdk090";
 *)
R2_d ( VDD, VDD, VDD );
gpdk090_resnsppoly #(.w(2u), .r(999.368), .l(4.985u)) (*
integer
library_binding = "gpdk090";
 *)
R16 ( net0157, VSS, VDD );
gpdk090_resnsppoly #(.w(2u), .r(2.00051K), .l(9.99u)) (*
integer
library_binding = "gpdk090";
integer elaboration_binding = "R0[2:9]";

 *)
R0_2 ( tap[1], tap[2], VDD ),
  R0_3 ( tap[2], tap[3], VDD ),
  R0_4 ( tap[3], tap[4], VDD ),
  R0_5 ( tap[4], tap[5], VDD ),
  R0_6 ( tap[5], tap[6], VDD ),
  R0_7 ( tap[6], tap[7], VDD ),
  R0_8 ( tap[7], tap[8], VDD ),
  R0_9 ( tap[8], tap[9], VDD );
gpdk090_resnsppoly #(.w(2u), .r(2.9993K), .l(14.985u)) (*
integer
library_binding = "gpdk090";
 *)
R1_1 ( net0177, A, VDD );
gpdk090_resnsppoly #(.w(2u), .r(2.9993K), .l(14.985u)) (*
integer
library_binding = "gpdk090";
 *)
R2_1 ( net0180, B, VDD );

gpdk090_pmos2v #(.ps(3.2u), .m(1 * 1), .as(600f), .l(280.0n), .pd(3.2u),
 .ad(600f), .w(1u)) (*
integer library_binding = "gpdk090";
integer
passed_mfactor = "m";
 *)
PM9 ( net91, SLEEPb, VDD, VDD );
gpdk090_pmos2v #(.ps(21.2u), .m(1 * 2), .as(6p), .l(2u), .pd(10.6u), .ad(3p),
 .w(10u)) (*
integer library_binding = "gpdk090";
integer
passed_mfactor = "m";
 *)
PM5 ( Ibias, Ibias, VDD, VDD );
gpdk090_pmos2v #(.ps(21.2u), .m(1 * 2), .as(6p), .l(2u), .pd(10.6u), .ad(3p),
 .w(10u)) (*
integer library_binding = "gpdk090";
integer
passed_mfactor = "m";
 *)
PM6 ( nbias, Ibias, VDD, VDD );
gpdk090_pmos2v #(.ps(3.53u), .m(1 * 1), .as(699f), .l(280.0n), .pd(3.53u),
 .ad(699f), .w(1.165u)) (*
integer library_binding = "gpdk090";

integer passed_mfactor = "m";
 *)
PM7 ( Ibias, SLEEPb, VDD, VDD );
gpdk090_pmos2v #(.ps(3.2u), .m(1 * 1), .as(600f), .l(280.0n), .pd(3.2u),
 .ad(600f), .w(1u)) (*
integer library_binding = "gpdk090";
integer
passed_mfactor = "m";
 *)
PM8 ( net37, SLEEPb, VDD, VDD );
gpdk090_pmos2v #(.ps(21.2u), .m(1 * 1), .as(6p), .l(6u), .pd(21.2u), .ad(6p),
 .w(10u)) (*
integer library_binding = "gpdk090";
integer
passed_mfactor = "m";
 *)
PM4 ( VREF, net0157, tap[9], VDD );
gpdk090_pmos2v #(.ps(21.2u), .m(2 * 1), .as(6p), .l(1u), .pd(21.2u), .ad(6p),
 .w(10u)) (*
integer library_binding = "gpdk090";
integer
passed_mfactor = "m";
 *)
PM1 ( net75, net37, VDD, VDD );
gpdk090_pmos2v #(.ps(21.2u), .m(2 * 1), .as(6p), .l(1u), .pd(21.2u), .ad(6p),
 .w(10u)) (*
integer library_binding = "gpdk090";
integer
passed_mfactor = "m";
 *)
PM0 ( COMP, net91, VDD, VDD );
gpdk090_pmos2v #(.ps(21.2u), .m(2 * 1), .as(6p), .l(1u), .pd(21.2u), .ad(6p),
 .w(10u)) (*
integer library_binding = "gpdk090";
integer
passed_mfactor = "m";
 *)
PM2 ( net37, net37, VDD, VDD );
gpdk090_pmos2v #(.ps(21.2u), .m(2 * 1), .as(6p), .l(1u), .pd(21.2u), .ad(6p),
 .w(10u)) (*
integer library_binding = "gpdk090";
integer
passed_mfactor = "m";
 *)
PM3 ( net91, net91, VDD, VDD );

gpdk090_nmos2v #(.ps(41.2u), .m(1 * 1), .as(12p), .l(300n), .pd(41.2u),
 .ad(12p), .w(20u)) (*
integer library_binding = "gpdk090";
integer
passed_mfactor = "m";
 *)
Dummy_1 ( VSS, VSS, VSS, VSS );
gpdk090_nmos2v #(.ps(41.2u), .m(1 * 1), .as(12p), .l(300n), .pd(41.2u),
 .ad(12p), .w(20u)) (*
integer library_binding = "gpdk090";
integer
passed_mfactor = "m";
 *)
Dummy_4 ( VSS, VSS, VSS, VSS );
gpdk090_nmos2v #(.ps(41.2u), .m(1 * 1), .as(12p), .l(300n), .pd(41.2u),
 .ad(12p), .w(20u)) (*
integer library_binding = "gpdk090";
integer
passed_mfactor = "m";
 *)
Dummy_3 ( VSS, VSS, VSS, VSS );
gpdk090_nmos2v #(.ps(41.2u), .m(1 * 1), .as(12p), .l(300n), .pd(41.2u),
 .ad(12p), .w(20u)) (*
integer library_binding = "gpdk090";
integer
passed_mfactor = "m";
 *)
Dummy_2 ( VSS, VSS, VSS, VSS );
gpdk090_nmos2v #(.ps(7.26u), .m(1 * 20), .as(1.98p), .l(280.0n), .pd(6.6u),
 .ad(1.8p), .w(6u)) (*
integer library_binding = "gpdk090";
integer
passed_mfactor = "m";
 *)
NM13 ( tap[50], SLEEPb, VSS, VSS );
gpdk090_nmos2v #(.ps(3.2u), .m(1 * 1), .as(600f), .l(280.0n), .pd(3.2u),
 .ad(600f), .w(1u)) (*
integer library_binding = "gpdk090";
integer
passed_mfactor = "m";
 *)
NM11 ( COMP, SLEEP, VSS, VSS );
gpdk090_nmos2v #(.ps(3.53u), .m(1 * 1), .as(699f), .l(280.0n), .pd(3.53u),
 .ad(699f), .w(1.165u)) (*
integer library_binding = "gpdk090";

integer passed_mfactor = "m";
 *)
NM10 ( nbias, SLEEP, VSS, VSS );
gpdk090_nmos2v #(.ps(3.2u), .m(1 * 1), .as(600f), .l(280.0n), .pd(3.2u),
 .ad(600f), .w(1u)) (*
integer library_binding = "gpdk090";
integer
passed_mfactor = "m";
 *)
NM2 ( net75, SLEEP, VSS, VSS );
gpdk090_nmos2v #(.ps(21.2u), .m(1 * 1), .as(6p), .l(1u), .pd(21.2u), .ad(6p),
 .w(10u)) (*
integer library_binding = "gpdk090";
integer
passed_mfactor = "m";
 *)
NM7 ( COMP, net75, VSS, VSS );
gpdk090_nmos2v #(.ps(21.2u), .m(1 * 1), .as(6p), .l(1u), .pd(21.2u), .ad(6p),
 .w(10u)) (*
integer library_binding = "gpdk090";
integer
passed_mfactor = "m";
 *)
NM6 ( net75, net75, VSS, VSS );
gpdk090_nmos2v #(.ps(41.2u), .m(2 * 1), .as(12p), .l(300n), .pd(41.2u),
 .ad(12p), .w(20u)) (*
integer library_binding = "gpdk090";
integer
passed_mfactor = "m";
 *)
NM3 ( net37, A, net90, VSS );
gpdk090_nmos2v #(.ps(41.2u), .m(2 * 1), .as(12p), .l(300n), .pd(41.2u),
 .ad(12p), .w(20u)) (*
integer library_binding = "gpdk090";
integer
passed_mfactor = "m";
 *)
NM1 ( net91, B, net90, VSS );
gpdk090_nmos2v #(.ps(31.2u), .m(1 * 1), .as(9p), .l(3u), .pd(31.2u), .ad(9p),
 .w(15u)) (*
integer library_binding = "gpdk090";
integer
passed_mfactor = "m";
 *)
NM9 ( nbias, nbias, VSS, VSS );
gpdk090_nmos2v #(.ps(31.2u), .m(1 * 2), .as(9p), .l(3u), .pd(15.6u), .ad(4.5p),
 .w(15u)) (*
integer library_binding = "gpdk090";
integer
passed_mfactor = "m";
 *)
NM0 ( net90, nbias, VSS, VSS );
gpdk090_nmos2v #(.ps(31.2u), .m(1 * 2), .as(9p), .l(3u), .pd(15.6u), .ad(4.5p),
 .w(15u)) (*
integer library_binding = "gpdk090";
integer
passed_mfactor = "m";
 *)
NM8 ( net86, nbias, VSS, VSS );
gpdk090_nmos2v #(.ps(41.2u), .m(2 * 1), .as(12p), .l(300n), .pd(41.2u),
 .ad(12p), .w(20u)) (*
integer library_binding = "gpdk090";
integer
passed_mfactor = "m";
 *)
NM4 ( B, VREF, net86, VSS );
gpdk090_nmos2v #(.ps(41.2u), .m(2 * 1), .as(12p), .l(300n), .pd(41.2u),
 .ad(12p), .w(20u)) (*
integer library_binding = "gpdk090";
integer
passed_mfactor = "m";
 *)
NM5 ( A, LFTAP, net86, VSS );

gpdk090_nmoscap2v #(.m(1 * 50), .l(4.07u), .w(4.055u)) (*
integer
library_binding = "gpdk090";
integer passed_mfactor = "m";
 *)
C1 (
VSS, VREF, VSS, VSS );
gpdk090_nmoscap2v #(.m(1 * 50), .l(4.07u), .w(4.055u)) (*
integer
library_binding = "gpdk090";
integer passed_mfactor = "m";
 *)
C0 (
VSS, VREF, VSS, VSS );

inv_1x_hv (*
integer library_binding = "ether";
integer cds_net_set
[0:1] = { "DVDD","DVSS" };
integer DVDD = "VDD";
integer DVSS
 = "VSS";
 *)
I9 ( .Y( SLEEP ), .A( SLEEPb ) );
inv_1x_hv (*
integer library_binding = "ether";
integer cds_net_set
[0:1] = { "DVSS","DVDD" };
integer DVSS = "VSS";
integer DVDD
 = "VDD";
 *)
I8 ( .Y( SLEEPb ), .A( PD ) );

endmodule
