// Verilog-AMS netlist generated by the AMS netlister, version ICOA5.2.51.500.7.
// Cadence Design Systems, Inc.

`include "disciplines.vams"

module adc_invertx1 ( IN,VDD,OUT,VSS );

input   IN;
input   VDD;
output   OUT;
input   VSS;

gpdk090_pmos2v #(.ps(5.87u), .m(1 * 1), .as(1.401p), .l(280.0n), .pd(5.87u),
 .ad(1.401p), .w(2.335u)) (*
integer library_binding = "gpdk090";

integer passed_mfactor = "m";
 *)
PM0 ( OUT, IN, VDD, VDD );

gpdk090_nmos2v #(.ps(3.53u), .m(1 * 1), .as(699f), .l(280.0n), .pd(3.53u),
 .ad(699f), .w(1.165u)) (*
integer library_binding = "gpdk090";

integer passed_mfactor = "m";
 *)
NM0 ( OUT, IN, VSS, VSS );

endmodule
