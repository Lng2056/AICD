// Verilog-AMS netlist generated by the AMS netlister, version ICOA5.2.51.500.7.
// Cadence Design Systems, Inc.

`include "disciplines.vams"

module Analog_eq_pole ( gnd,vdd,pole,plus,minus );

inout   gnd;
inout   vdd;
input [1:0]  pole;
input   plus;
input
 minus;

gpdk090_pmoscap2v #(.m(1 * 9), .l(4.9u), .w(4.59u)) (*
integer
library_binding = "gpdk090";
integer passed_mfactor = "m";
 *)
C4 (
vdd, net62, vdd, vdd );
gpdk090_pmoscap2v #(.m(1 * 3), .l(5.63u), .w(5.27u)) (*
integer
library_binding = "gpdk090";
integer passed_mfactor = "m";
 *)
C0 (
vdd, net51, vdd, vdd );
gpdk090_pmoscap2v #(.m(1 * 2), .l(485n), .w(780n)) (*
integer
library_binding = "gpdk090";
integer passed_mfactor = "m";
 *)
C5 (
vdd, vdd, vdd, vdd );
gpdk090_pmoscap2v #(.m(1 * 2), .l(3.945u), .w(3.7u)) (*
integer
library_binding = "gpdk090";
integer passed_mfactor = "m";
 *)
C2 (
vdd, vdd, vdd, vdd );
gpdk090_pmoscap2v #(.m(1 * 3), .l(5.63u), .w(5.27u)) (*
integer
library_binding = "gpdk090";
integer passed_mfactor = "m";
 *)
C3 (
vdd, net68, vdd, vdd );
gpdk090_pmoscap2v #(.m(1 * 9), .l(4.9u), .w(4.59u)) (*
integer
library_binding = "gpdk090";
integer passed_mfactor = "m";
 *)
C1 (
vdd, net55, vdd, vdd );

gpdk090_pmos2v #(.ps(3.53u), .m(1 * 1), .as(699f), .l(280.0n), .pd(3.53u),
 .ad(699f), .w(1.165u)) (*
integer library_binding = "gpdk090";

integer passed_mfactor = "m";
 *)
PM0 ( net51, pole[0], vdd, vdd );
gpdk090_pmos2v #(.ps(3.53u), .m(1 * 1), .as(699f), .l(280.0n), .pd(3.53u),
 .ad(699f), .w(1.165u)) (*
integer library_binding = "gpdk090";

integer passed_mfactor = "m";
 *)
PM1 ( vdd, pole[0], net68, vdd );
gpdk090_pmos2v #(.ps(3.53u), .m(1 * 1), .as(699f), .l(280.0n), .pd(3.53u),
 .ad(699f), .w(1.165u)) (*
integer library_binding = "gpdk090";

integer passed_mfactor = "m";
 *)
PM2 ( vdd, pole[1], net62, vdd );
gpdk090_pmos2v #(.ps(3.53u), .m(1 * 1), .as(699f), .l(280.0n), .pd(3.53u),
 .ad(699f), .w(1.165u)) (*
integer library_binding = "gpdk090";

integer passed_mfactor = "m";
 *)
PM3 ( net55, pole[1], vdd, vdd );

gpdk090_nmos2v #(.ps(24.53u), .m(1 * 1), .as(6.999p), .l(280.0n), .pd(24.53u),
 .ad(6.999p), .w(11.665u)) (*
integer library_binding = "gpdk090";

integer passed_mfactor = "m";
 *)
NM1 ( minus, pole[1], net62, gnd );
gpdk090_nmos2v #(.ps(24.53u), .m(1 * 1), .as(6.999p), .l(280.0n), .pd(24.53u),
 .ad(6.999p), .w(11.665u)) (*
integer library_binding = "gpdk090";

integer passed_mfactor = "m";
 *)
NM2 ( minus, pole[0], net68, gnd );
gpdk090_nmos2v #(.ps(24.53u), .m(1 * 1), .as(6.999p), .l(280.0n), .pd(24.53u),
 .ad(6.999p), .w(11.665u)) (*
integer library_binding = "gpdk090";

integer passed_mfactor = "m";
 *)
NM3 ( net51, pole[0], plus, gnd );
gpdk090_nmos2v #(.ps(24.53u), .m(1 * 1), .as(6.999p), .l(280.0n), .pd(24.53u),
 .ad(6.999p), .w(11.665u)) (*
integer library_binding = "gpdk090";

integer passed_mfactor = "m";
 *)
NM0 ( net55, pole[1], plus, gnd );

endmodule
