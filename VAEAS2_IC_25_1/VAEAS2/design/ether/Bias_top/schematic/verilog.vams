// Verilog-AMS netlist generated by the AMS netlister, version ICOA5.2.51.500.7.
// Cadence Design Systems, Inc.

`include "disciplines.vams"

module Bias_top ( I_25u_Rpoly_PLL,I_400u_Rext,vss,I_100u_Rpoly,
I_100u_Rext,Vkelvin,vdd,siddq,I_100u_Rext_PLL,I_25u_Rext_PLL,Rext,
BGTRIM );

output [1:0]  I_25u_Rpoly_PLL;
output   I_400u_Rext;
input   vss;

output   I_100u_Rpoly;
output   I_100u_Rext;
inout   Vkelvin;
input
 vdd;
input   siddq;
output [1:0]  I_100u_Rext_PLL;
output [1:0]
 I_25u_Rext_PLL;
inout   Rext;
input [3:0]  BGTRIM;

gpdk090_resnsppoly #(.w(2u), .r(2.03886K), .l(10.185u)) (*
integer
library_binding = "gpdk090";
 *)
R3 ( net093, net076, vss );
gpdk090_resnsppoly #(.w(2u), .r(2.03886K), .l(10.185u)) (*
integer
library_binding = "gpdk090";
 *)
R1 ( net045, net70, vss );
gpdk090_resnsppoly #(.w(2u), .r(2.03886K), .l(10.185u)) (*
integer
library_binding = "gpdk090";
 *)
R5 ( net089, net083, vss );
gpdk090_resnsppoly #(.w(2u), .r(2.03886K), .l(10.185u)) (*
integer
library_binding = "gpdk090";
 *)
R6 ( vss, vss, vss );
gpdk090_resnsppoly #(.w(2u), .r(2.03886K), .l(10.185u)) (*
integer
library_binding = "gpdk090";
 *)
R7 ( net70, net70, vss );
gpdk090_resnsppoly #(.w(2u), .r(2.03886K), .l(10.185u)) (*
integer
library_binding = "gpdk090";
 *)
R4 ( net083, vss, vss );
gpdk090_resnsppoly #(.w(2u), .r(2.03886K), .l(10.185u)) (*
integer
library_binding = "gpdk090";
 *)
R2 ( net076, net045, vss );
gpdk090_resnsppoly #(.w(2u), .r(2.03886K), .l(10.185u)) (*
integer
library_binding = "gpdk090";
 *)
R0 ( net093, net089, vss );

gpdk090_nmos2v #(.ps(3.52u), .m(1 * 1), .as(696f), .l(280.0n), .pd(3.52u),
 .ad(696f), .w(1.16u)) (*
integer library_binding = "gpdk090";

integer passed_mfactor = "m";
 *)
NM0 ( net0106, siddq_buf, vss, vss );

clkbuf_4x_hv (*
integer library_binding = "ether";
integer cds_net_set
[0:1] = { "DVDD","DVSS" };
integer DVDD = "vdd";
integer DVSS
 = "vss";
 *)
I26 ( .Y( siddq_buf ), .A( siddq ) );

Bias_bg_current_source2_2 (*
integer library_binding = "ether";
 *)

I_CURRENT22 ( .I_25u_Rpoly_PLL( I_25u_Rpoly_PLL[1:0] ), .Vref( net0106 ),
.RPOLY_OUT( net70 ), .CASC_AC_IN( net064 ), .vss( vss ), .I_100u_Rpoly(
I_100u_Rpoly ), .VDD( vdd ), .RPOLY_IN( net70 ), .siddq( siddq_buf ),
.CASC_AC_OUT( net064 ), .Ibias( bias1 ) );

Bias_bg_current_source1_2 (*
integer library_binding = "ether";
 *)

I_CURRENT12 ( .Vref( net0106 ), .I_400u_Rext( I_400u_Rext ), .CASC_AC_IN(
net070 ), .I_100u_Rext( I_100u_Rext ), .vss( vss ), .Vkelvin( Vkelvin ),
.VDD( vdd ), .siddq( siddq_buf ), .I_100u_Rext_PLL(
I_100u_Rext_PLL[1:0] ), .I_25u_Rext_PLL( I_25u_Rext_PLL[1:0] ), .Rext(
Rext ), .CASC_AC_OUT( net070 ), .Ibias( bias0 ) );

Bias_bg_Vt_current_ref2 (*
integer library_binding = "ether";
 *)

I_VT_BIAS ( .Iout0( bias0 ), .VDD( vdd ), .siddq( siddq_buf ), .VSS(
vss ), .Iout1( bias1 ) );

Bias_bandgap (*
integer library_binding = "ether";
 *)
I_BG_BIAS ( .SIDDQ(
siddq_buf ), .TRIM( BGTRIM[3:0] ), .VBG( net0106 ), .VDD( vdd ), .AC_IN(
BG_AC ), .VSS( vss ), .AC_OUT( BG_AC ) );

endmodule
