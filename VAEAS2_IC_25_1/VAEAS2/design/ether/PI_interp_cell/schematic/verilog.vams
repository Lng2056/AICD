// Verilog-AMS netlist generated by the AMS netlister, version ICOA5.2.51.500.7.
// Cadence Design Systems, Inc.

`include "disciplines.vams"

module PI_interp_cell ( IN,Tap,VDD,OUT,VSS );

input [1:0]  IN;
output [1:0]  Tap;
input   VDD;
output [2:0]  OUT;

input   VSS;

gpdk090_pmos2v #(.ps(7.5u), .m(1 * 1), .as(1.89p), .l(280.0n), .pd(7.5u),
 .ad(1.89p), .w(3.15u)) (*
integer library_binding = "gpdk090";

integer passed_mfactor = "m";
 *)
PM10 ( net096, Tap[1], VDD, VDD );
gpdk090_pmos2v #(.ps(7.5u), .m(1 * 1), .as(1.89p), .l(280.0n), .pd(7.5u),
 .ad(1.89p), .w(3.15u)) (*
integer library_binding = "gpdk090";

integer passed_mfactor = "m";
 *)
PM9 ( OUT[1], net096, VDD, VDD );
gpdk090_pmos2v #(.ps(7.5u), .m(1 * 1), .as(1.89p), .l(280.0n), .pd(7.5u),
 .ad(1.89p), .w(3.15u)) (*
integer library_binding = "gpdk090";

integer passed_mfactor = "m";
 *)
PM8 ( net096, Tap[0], VDD, VDD );
gpdk090_pmos2v #(.ps(7.5u), .m(1 * 1), .as(1.89p), .l(280.0n), .pd(7.5u),
 .ad(1.89p), .w(3.15u)) (*
integer library_binding = "gpdk090";

integer passed_mfactor = "m";
 *)
PM4 ( OUT[2], net055, VDD, VDD );
gpdk090_pmos2v #(.ps(7.5u), .m(1 * 1), .as(1.89p), .l(280.0n), .pd(7.5u),
 .ad(1.89p), .w(3.15u)) (*
integer library_binding = "gpdk090";

integer passed_mfactor = "m";
 *)
PM7 ( net047, IN[1], VDD, VDD );
gpdk090_pmos2v #(.ps(7.5u), .m(1 * 1), .as(1.89p), .l(280.0n), .pd(7.5u),
 .ad(1.89p), .w(3.15u)) (*
integer library_binding = "gpdk090";

integer passed_mfactor = "m";
 *)
PM5 ( net055, Tap[1], VDD, VDD );
gpdk090_pmos2v #(.ps(7.5u), .m(1 * 1), .as(1.89p), .l(280.0n), .pd(7.5u),
 .ad(1.89p), .w(3.15u)) (*
integer library_binding = "gpdk090";

integer passed_mfactor = "m";
 *)
PM6 ( Tap[1], net047, VDD, VDD );
gpdk090_pmos2v #(.ps(7.5u), .m(1 * 1), .as(1.89p), .l(280.0n), .pd(7.5u),
 .ad(1.89p), .w(3.15u)) (*
integer library_binding = "gpdk090";

integer passed_mfactor = "m";
 *)
PM3 ( OUT[0], net11, VDD, VDD );
gpdk090_pmos2v #(.ps(7.5u), .m(1 * 1), .as(1.89p), .l(280.0n), .pd(7.5u),
 .ad(1.89p), .w(3.15u)) (*
integer library_binding = "gpdk090";

integer passed_mfactor = "m";
 *)
PM2 ( net11, Tap[0], VDD, VDD );
gpdk090_pmos2v #(.ps(7.5u), .m(1 * 1), .as(1.89p), .l(280.0n), .pd(7.5u),
 .ad(1.89p), .w(3.15u)) (*
integer library_binding = "gpdk090";

integer passed_mfactor = "m";
 *)
PM1 ( Tap[0], net19, VDD, VDD );
gpdk090_pmos2v #(.ps(7.5u), .m(1 * 1), .as(1.89p), .l(280.0n), .pd(7.5u),
 .ad(1.89p), .w(3.15u)) (*
integer library_binding = "gpdk090";

integer passed_mfactor = "m";
 *)
PM0 ( net19, IN[0], VDD, VDD );

gpdk090_nmos2v #(.ps(3.53u), .m(1 * 1), .as(699f), .l(280.0n), .pd(3.53u),
 .ad(699f), .w(1.165u)) (*
integer library_binding = "gpdk090";

integer passed_mfactor = "m";
 *)
NM1 ( Tap[0], net19, VSS, VSS );
gpdk090_nmos2v #(.ps(3.53u), .m(1 * 1), .as(699f), .l(280.0n), .pd(3.53u),
 .ad(699f), .w(1.165u)) (*
integer library_binding = "gpdk090";

integer passed_mfactor = "m";
 *)
NM0 ( net19, IN[0], VSS, VSS );
gpdk090_nmos2v #(.ps(3.53u), .m(1 * 1), .as(699f), .l(280.0n), .pd(3.53u),
 .ad(699f), .w(1.165u)) (*
integer library_binding = "gpdk090";

integer passed_mfactor = "m";
 *)
NM10 ( net096, Tap[1], VSS, VSS );
gpdk090_nmos2v #(.ps(3.53u), .m(1 * 1), .as(699f), .l(280.0n), .pd(3.53u),
 .ad(699f), .w(1.165u)) (*
integer library_binding = "gpdk090";

integer passed_mfactor = "m";
 *)
NM8 ( net096, Tap[0], VSS, VSS );
gpdk090_nmos2v #(.ps(3.53u), .m(1 * 1), .as(699f), .l(280.0n), .pd(3.53u),
 .ad(699f), .w(1.165u)) (*
integer library_binding = "gpdk090";

integer passed_mfactor = "m";
 *)
NM7 ( net047, IN[1], VSS, VSS );
gpdk090_nmos2v #(.ps(3.53u), .m(1 * 1), .as(699f), .l(280.0n), .pd(3.53u),
 .ad(699f), .w(1.165u)) (*
integer library_binding = "gpdk090";

integer passed_mfactor = "m";
 *)
NM9 ( OUT[1], net096, VSS, VSS );
gpdk090_nmos2v #(.ps(3.53u), .m(1 * 1), .as(699f), .l(280.0n), .pd(3.53u),
 .ad(699f), .w(1.165u)) (*
integer library_binding = "gpdk090";

integer passed_mfactor = "m";
 *)
NM5 ( net055, Tap[1], VSS, VSS );
gpdk090_nmos2v #(.ps(3.53u), .m(1 * 1), .as(699f), .l(280.0n), .pd(3.53u),
 .ad(699f), .w(1.165u)) (*
integer library_binding = "gpdk090";

integer passed_mfactor = "m";
 *)
NM6 ( Tap[1], net047, VSS, VSS );
gpdk090_nmos2v #(.ps(3.53u), .m(1 * 1), .as(699f), .l(280.0n), .pd(3.53u),
 .ad(699f), .w(1.165u)) (*
integer library_binding = "gpdk090";

integer passed_mfactor = "m";
 *)
NM4 ( OUT[2], net055, VSS, VSS );
gpdk090_nmos2v #(.ps(3.53u), .m(1 * 1), .as(699f), .l(280.0n), .pd(3.53u),
 .ad(699f), .w(1.165u)) (*
integer library_binding = "gpdk090";

integer passed_mfactor = "m";
 *)
NM3 ( OUT[0], net11, VSS, VSS );
gpdk090_nmos2v #(.ps(3.53u), .m(1 * 1), .as(699f), .l(280.0n), .pd(3.53u),
 .ad(699f), .w(1.165u)) (*
integer library_binding = "gpdk090";

integer passed_mfactor = "m";
 *)
NM2 ( net11, Tap[0], VSS, VSS );

gpdk090_nmoscap2v #(.m(1 * 1), .l(1.5u), .w(5.5u)) (*
integer
library_binding = "gpdk090";
integer passed_mfactor = "m";
 *)
C5 (
VSS, net11, VSS, VSS );
gpdk090_nmoscap2v #(.m(1 * 2), .l(1.5u), .w(5.065u)) (*
integer
library_binding = "gpdk090";
integer passed_mfactor = "m";
 *)
C9 (
VSS, net096, VSS, VSS );
gpdk090_nmoscap2v #(.m(1 * 1), .l(1.5u), .w(5.5u)) (*
integer
library_binding = "gpdk090";
integer passed_mfactor = "m";
 *)
C7 (
VSS, net055, VSS, VSS );
gpdk090_nmoscap2v #(.m(1 * 2), .l(1.5u), .w(5.5u)) (*
integer
library_binding = "gpdk090";
integer passed_mfactor = "m";
 *)
C3 (
VSS, Tap[1], VSS, VSS );
gpdk090_nmoscap2v #(.m(1 * 2), .l(1.5u), .w(5.5u)) (*
integer
library_binding = "gpdk090";
integer passed_mfactor = "m";
 *)
C0 (
VSS, Tap[0], VSS, VSS );

gpdk090_pmoscap2v #(.m(1 * 1), .l(1.5u), .w(5.4u)) (*
integer
library_binding = "gpdk090";
integer passed_mfactor = "m";
 *)
C6 (
VDD, net055, VDD, VDD );
gpdk090_pmoscap2v #(.m(1 * 2), .l(1.5u), .w(5.4u)) (*
integer
library_binding = "gpdk090";
integer passed_mfactor = "m";
 *)
C2 (
VDD, Tap[1], VDD, VDD );
gpdk090_pmoscap2v #(.m(1 * 2), .l(1.5u), .w(4.965u)) (*
integer
library_binding = "gpdk090";
integer passed_mfactor = "m";
 *)
C8 (
VDD, net096, VDD, VDD );
gpdk090_pmoscap2v #(.m(1 * 2), .l(1.5u), .w(5.4u)) (*
integer
library_binding = "gpdk090";
integer passed_mfactor = "m";
 *)
C1 (
VDD, Tap[0], VDD, VDD );
gpdk090_pmoscap2v #(.m(1 * 1), .l(1.5u), .w(5.4u)) (*
integer
library_binding = "gpdk090";
integer passed_mfactor = "m";
 *)
C4 (
VDD, net11, VDD, VDD );

endmodule
