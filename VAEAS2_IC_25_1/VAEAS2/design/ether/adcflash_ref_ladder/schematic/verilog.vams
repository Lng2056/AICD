// Verilog-AMS netlist generated by the AMS netlister, version ICOA5.2.51.500.7.
// Cadence Design Systems, Inc.

`include "disciplines.vams"

module adcflash_ref_ladder ( ref0,ref1,ref2,ref3,ref4,ref5,ref6,ref7,
ref8,ref9,ref10,INM,INP,SIDDQ,VDD,VSS,ibias50 );

output   ref0;
output   ref1;
output   ref2;
output   ref3;
output
 ref4;
output   ref5;
output   ref6;
output   ref7;
output   ref8;

output   ref9;
input   ref10;
input   INM;
input   INP;
input
 SIDDQ;
input   VDD;
input   VSS;
input   ibias50;

parameter vcm=1.365;
parameter voffset=0;
parameter r_ladder=1000;

gpdk090_resnsppoly #(.w(4u), .r(1.01943K), .l(10.185u)) (*
integer
library_binding = "gpdk090";
integer elaboration_binding = "R3[1:0]";

 *)
R3_1 ( ref10, ref9, VDD ),
  R3_0 ( ref10, ref9, VDD );
gpdk090_resnsppoly #(.w(4u), .r(1.01943K), .l(10.185u)) (*
integer
library_binding = "gpdk090";
integer elaboration_binding = "R7[1:0]";

 *)
R7_1 ( ref9, ref8, VDD ),
  R7_0 ( ref9, ref8, VDD );
gpdk090_resnsppoly #(.w(4u), .r(1.01943K), .l(10.185u)) (*
integer
library_binding = "gpdk090";
integer elaboration_binding = "R8[4:0]";

 *)
R8_4 ( ref8, ref7, VDD ),
  R8_3 ( ref8, ref7, VDD ),
  R8_2 ( ref8, ref7, VDD ),
  R8_1 ( ref8, ref7, VDD ),
  R8_0 ( ref8, ref7, VDD );
gpdk090_resnsppoly #(.w(4u), .r(1.01943K), .l(10.185u)) (*
integer
library_binding = "gpdk090";
integer elaboration_binding
 = "R12[4:0]";
 *)
R12_4 ( ref7, ref6, VDD ),
  R12_3 ( ref7, ref6, VDD ),
  R12_2 ( ref7, ref6, VDD ),
  R12_1 ( ref7, ref6, VDD ),
  R12_0 ( ref7, ref6, VDD );
gpdk090_resnsppoly #(.w(4u), .r(1.01943K), .l(10.185u)) (*
integer
library_binding = "gpdk090";
integer elaboration_binding
 = "R13[1:0]";
 *)
R13_1 ( ref6, ref5, VDD ),
  R13_0 ( ref6, ref5, VDD );
gpdk090_resnsppoly #(.w(4u), .r(1.01943K), .l(10.185u)) (*
integer
library_binding = "gpdk090";
integer elaboration_binding
 = "R17[1:0]";
 *)
R17_1 ( ref5, ref4, VDD ),
  R17_0 ( ref5, ref4, VDD );
gpdk090_resnsppoly #(.w(4u), .r(1.01943K), .l(10.185u)) (*
integer
library_binding = "gpdk090";
integer elaboration_binding
 = "R18[4:0]";
 *)
R18_4 ( ref4, ref3, VDD ),
  R18_3 ( ref4, ref3, VDD ),
  R18_2 ( ref4, ref3, VDD ),
  R18_1 ( ref4, ref3, VDD ),
  R18_0 ( ref4, ref3, VDD );
gpdk090_resnsppoly #(.w(4u), .r(1.01943K), .l(10.185u)) (*
integer
library_binding = "gpdk090";
integer elaboration_binding
 = "R19[4:0]";
 *)
R19_4 ( ref3, ref2, VDD ),
  R19_3 ( ref3, ref2, VDD ),
  R19_2 ( ref3, ref2, VDD ),
  R19_1 ( ref3, ref2, VDD ),
  R19_0 ( ref3, ref2, VDD );
gpdk090_resnsppoly #(.w(4u), .r(1.01943K), .l(10.185u)) (*
integer
library_binding = "gpdk090";
integer elaboration_binding
 = "R20[1:0]";
 *)
R20_1 ( ref2, ref1, VDD ),
  R20_0 ( ref2, ref1, VDD );
gpdk090_resnsppoly #(.w(4u), .r(1.01943K), .l(10.185u)) (*
integer
library_binding = "gpdk090";
integer elaboration_binding
 = "R21[1:0]";
 *)
R21_1 ( ref1, ref0, VDD ),
  R21_0 ( ref1, ref0, VDD );
gpdk090_resnsppoly #(.w(2u), .r(19.9992K), .l(100.02u)) (*
integer
library_binding = "gpdk090";
 *)
R11 ( INM, net59, VDD );
gpdk090_resnsppoly #(.w(2u), .r(19.9992K), .l(100.02u)) (*
integer
library_binding = "gpdk090";
 *)
R1 ( INP, net59, VDD );

gpdk090_pmos2v #(.ps(17.16u), .m(1 * 20), .as(4.95p), .l(280.0n), .pd(15.6u),
 .ad(4.5p), .w(15u)) (*
integer library_binding = "gpdk090";
integer
passed_mfactor = "m";
 *)
PM0 ( VSS, net20, ref0, ref0 );

gpdk090_pmoscap2v #(.m(4 * 8), .l(6.575u), .w(6.165u)) (*
integer
library_binding = "gpdk090";
integer passed_mfactor = "m";
 *)
C0 (
VDD, net20, VDD, VDD );

adc_cascode_opamp (*
integer library_binding = "ether";
 *)
I2 ( .INP(
net59 ), .SIDDQ( SIDDQ ), .INN( ref5 ), .IREF( ibias50 ), .VDD( VDD ),
.OUT( net20 ), .VSS( VSS ) );

endmodule
