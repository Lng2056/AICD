// Verilog-AMS netlist generated by the AMS netlister, version ICOA5.2.51.500.7.
// Cadence Design Systems, Inc.

`include "disciplines.vams"

module tgate_5X ( vss,vdd,in,EN,out,ENB );

input   vss;
input   vdd;
inout   in;
input   EN;
inout   out;

input   ENB;

gpdk090_nmos2v #(.ps(12.87u), .m(1 * 1), .as(3.501p), .l(280.0n), .pd(12.87u),
 .ad(3.501p), .w(5.835u)) (*
integer library_binding = "gpdk090";

integer passed_mfactor = "m";
 *)
M1 ( in, EN, out, vss );

gpdk090_pmos2v #(.ps(8.58u), .m(1 * 3), .as(2.334p), .l(280.0n), .pd(8.58u),
 .ad(2.334p), .w(5.835u)) (*
integer library_binding = "gpdk090";

integer passed_mfactor = "m";
 *)
M0 ( out, ENB, in, vdd );

endmodule
