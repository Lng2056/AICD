// Verilog-AMS netlist generated by the AMS netlister, version ICOA5.2.51.500.7.
// Cadence Design Systems, Inc.

`include "disciplines.vams"

module clkbuf_16x_hv ( Y,A );

output   Y;
input   A;

wire (*
integer inh_conn_prop_name = "DVDD";
integer
inh_conn_def_value = "cds_globals.\\VDD! ";
 *)
\VDD! ;
wire (*
integer inh_conn_prop_name = "DVSS";
integer
inh_conn_def_value = "cds_globals.\\VSS! ";
 *)
\VSS! ;

gpdk090_pmos2v #(.ps(4.25u), .m(1 * 8), .as(1.05p), .l(280.0n), .pd(3.4u),
 .ad(840f), .w(2.8u)) (*
integer library_binding = "gpdk090";
integer
passed_mfactor = "m";
 *)
PM1 ( Y, net27, \VDD! , \VDD!  );
gpdk090_pmos2v #(.ps(4.53333u), .m(1 * 3), .as(1.12p), .l(280.0n), .pd(4.53333u),
 .ad(1.12p), .w(2.8u)) (*
integer library_binding = "gpdk090";

integer passed_mfactor = "m";
 *)
PM0 ( net27, A, \VDD! , \VDD!  );

gpdk090_nmos2v #(.ps(2.29333u), .m(1 * 3), .as(448f), .l(280.0n), .pd(2.29333u),
 .ad(448f), .w(1.12u)) (*
integer library_binding = "gpdk090";

integer passed_mfactor = "m";
 *)
NM0 ( net27, A, \VSS! , \VSS!  );
gpdk090_nmos2v #(.ps(2.15u), .m(1 * 8), .as(420f), .l(280.0n), .pd(1.72u),
 .ad(336f), .w(1.12u)) (*
integer library_binding = "gpdk090";

integer passed_mfactor = "m";
 *)
NM1 ( Y, net27, \VSS! , \VSS!  );

endmodule
