// Verilog-AMS netlist generated by the AMS netlister, version ICOA5.2.51.500.7.
// Cadence Design Systems, Inc.

`include "disciplines.vams"

module adc_lvlshft_2p5_to_1p0 ( FX_BIT_2p5,adc_2p5,ph1b_2p5,flash_2p5,
vss,adc_1p0,VDD_1p0,ph1_2p5,ph1b_1p0,FX_BIT_1p0,VDD_2p5,ph1_1p0,
flash_1p0 );

input   FX_BIT_2p5;
input [62:0]  adc_2p5;
input   ph1b_2p5;

input [5:0]  flash_2p5;
input   vss;
output [62:0]  adc_1p0;
input
 VDD_1p0;
input   ph1_2p5;
output   ph1b_1p0;
output   FX_BIT_1p0;

input   VDD_2p5;
output   ph1_1p0;
output [5:0]  flash_1p0;

level_shifter_2p5_1p0 #(.d2a_tr("200p"), .ieIO("output"), .a2d_v0(".5"),
 .d2a_tf("200p"), .a2d_v1("0.8"), .a2d_tx("100p"), .d2a_vh("2.5")) (*

integer library_binding = "ether";
 *)
I6 ( .IN( FX_BIT_2p5 ), .VDD_1p0(
VDD_1p0 ), .VDD_2p5( VDD_2p5 ), .OUT( FX_BIT_1p0 ), .VSS( vss ) );
level_shifter_2p5_1p0 #(.d2a_tr("200p"), .ieIO("output"), .a2d_v0(".5"),
 .d2a_tf("200p"), .a2d_v1(".8"), .a2d_tx("100p"), .d2a_vh("2.5")) (*

integer library_binding = "ether";
 *)
I_ph1b ( .IN( ph1b_2p5 ), .VDD_1p0(
VDD_1p0 ), .VDD_2p5( VDD_2p5 ), .OUT( ph1b_1p0 ), .VSS( vss ) );
level_shifter_2p5_1p0 #(.d2a_tr("200p"), .ieIO("output"), .a2d_v0(".6"),
 .d2a_tf("200p"), .a2d_v1(".8"), .a2d_tx("100p"), .d2a_vh("2.5")) (*

integer library_binding = "ether";
integer elaboration_binding
 = "I_adc[62:0]";
 *)
I_adc_62 ( .IN( adc_2p5[62] ), .VDD_1p0( VDD_1p0 ),
.VDD_2p5( VDD_2p5 ), .OUT( adc_1p0[62] ), .VSS( vss ) ),
  I_adc_61 ( .IN( adc_2p5[61] ), .VDD_1p0( VDD_1p0 ), .VDD_2p5(
VDD_2p5 ), .OUT( adc_1p0[61] ), .VSS( vss ) ),
  I_adc_60 ( .IN( adc_2p5[60] ), .VDD_1p0( VDD_1p0 ), .VDD_2p5(
VDD_2p5 ), .OUT( adc_1p0[60] ), .VSS( vss ) ),
  I_adc_59 ( .IN( adc_2p5[59] ), .VDD_1p0( VDD_1p0 ), .VDD_2p5(
VDD_2p5 ), .OUT( adc_1p0[59] ), .VSS( vss ) ),
  I_adc_58 ( .IN( adc_2p5[58] ), .VDD_1p0( VDD_1p0 ), .VDD_2p5(
VDD_2p5 ), .OUT( adc_1p0[58] ), .VSS( vss ) ),
  I_adc_57 ( .IN( adc_2p5[57] ), .VDD_1p0( VDD_1p0 ), .VDD_2p5(
VDD_2p5 ), .OUT( adc_1p0[57] ), .VSS( vss ) ),
  I_adc_56 ( .IN( adc_2p5[56] ), .VDD_1p0( VDD_1p0 ), .VDD_2p5(
VDD_2p5 ), .OUT( adc_1p0[56] ), .VSS( vss ) ),
  I_adc_55 ( .IN( adc_2p5[55] ), .VDD_1p0( VDD_1p0 ), .VDD_2p5(
VDD_2p5 ), .OUT( adc_1p0[55] ), .VSS( vss ) ),
  I_adc_54 ( .IN( adc_2p5[54] ), .VDD_1p0( VDD_1p0 ), .VDD_2p5(
VDD_2p5 ), .OUT( adc_1p0[54] ), .VSS( vss ) ),
  I_adc_53 ( .IN( adc_2p5[53] ), .VDD_1p0( VDD_1p0 ), .VDD_2p5(
VDD_2p5 ), .OUT( adc_1p0[53] ), .VSS( vss ) ),
  I_adc_52 ( .IN( adc_2p5[52] ), .VDD_1p0( VDD_1p0 ), .VDD_2p5(
VDD_2p5 ), .OUT( adc_1p0[52] ), .VSS( vss ) ),
  I_adc_51 ( .IN( adc_2p5[51] ), .VDD_1p0( VDD_1p0 ), .VDD_2p5(
VDD_2p5 ), .OUT( adc_1p0[51] ), .VSS( vss ) ),
  I_adc_50 ( .IN( adc_2p5[50] ), .VDD_1p0( VDD_1p0 ), .VDD_2p5(
VDD_2p5 ), .OUT( adc_1p0[50] ), .VSS( vss ) ),
  I_adc_49 ( .IN( adc_2p5[49] ), .VDD_1p0( VDD_1p0 ), .VDD_2p5(
VDD_2p5 ), .OUT( adc_1p0[49] ), .VSS( vss ) ),
  I_adc_48 ( .IN( adc_2p5[48] ), .VDD_1p0( VDD_1p0 ), .VDD_2p5(
VDD_2p5 ), .OUT( adc_1p0[48] ), .VSS( vss ) ),
  I_adc_47 ( .IN( adc_2p5[47] ), .VDD_1p0( VDD_1p0 ), .VDD_2p5(
VDD_2p5 ), .OUT( adc_1p0[47] ), .VSS( vss ) ),
  I_adc_46 ( .IN( adc_2p5[46] ), .VDD_1p0( VDD_1p0 ), .VDD_2p5(
VDD_2p5 ), .OUT( adc_1p0[46] ), .VSS( vss ) ),
  I_adc_45 ( .IN( adc_2p5[45] ), .VDD_1p0( VDD_1p0 ), .VDD_2p5(
VDD_2p5 ), .OUT( adc_1p0[45] ), .VSS( vss ) ),
  I_adc_44 ( .IN( adc_2p5[44] ), .VDD_1p0( VDD_1p0 ), .VDD_2p5(
VDD_2p5 ), .OUT( adc_1p0[44] ), .VSS( vss ) ),
  I_adc_43 ( .IN( adc_2p5[43] ), .VDD_1p0( VDD_1p0 ), .VDD_2p5(
VDD_2p5 ), .OUT( adc_1p0[43] ), .VSS( vss ) ),
  I_adc_42 ( .IN( adc_2p5[42] ), .VDD_1p0( VDD_1p0 ), .VDD_2p5(
VDD_2p5 ), .OUT( adc_1p0[42] ), .VSS( vss ) ),
  I_adc_41 ( .IN( adc_2p5[41] ), .VDD_1p0( VDD_1p0 ), .VDD_2p5(
VDD_2p5 ), .OUT( adc_1p0[41] ), .VSS( vss ) ),
  I_adc_40 ( .IN( adc_2p5[40] ), .VDD_1p0( VDD_1p0 ), .VDD_2p5(
VDD_2p5 ), .OUT( adc_1p0[40] ), .VSS( vss ) ),
  I_adc_39 ( .IN( adc_2p5[39] ), .VDD_1p0( VDD_1p0 ), .VDD_2p5(
VDD_2p5 ), .OUT( adc_1p0[39] ), .VSS( vss ) ),
  I_adc_38 ( .IN( adc_2p5[38] ), .VDD_1p0( VDD_1p0 ), .VDD_2p5(
VDD_2p5 ), .OUT( adc_1p0[38] ), .VSS( vss ) ),
  I_adc_37 ( .IN( adc_2p5[37] ), .VDD_1p0( VDD_1p0 ), .VDD_2p5(
VDD_2p5 ), .OUT( adc_1p0[37] ), .VSS( vss ) ),
  I_adc_36 ( .IN( adc_2p5[36] ), .VDD_1p0( VDD_1p0 ), .VDD_2p5(
VDD_2p5 ), .OUT( adc_1p0[36] ), .VSS( vss ) ),
  I_adc_35 ( .IN( adc_2p5[35] ), .VDD_1p0( VDD_1p0 ), .VDD_2p5(
VDD_2p5 ), .OUT( adc_1p0[35] ), .VSS( vss ) ),
  I_adc_34 ( .IN( adc_2p5[34] ), .VDD_1p0( VDD_1p0 ), .VDD_2p5(
VDD_2p5 ), .OUT( adc_1p0[34] ), .VSS( vss ) ),
  I_adc_33 ( .IN( adc_2p5[33] ), .VDD_1p0( VDD_1p0 ), .VDD_2p5(
VDD_2p5 ), .OUT( adc_1p0[33] ), .VSS( vss ) ),
  I_adc_32 ( .IN( adc_2p5[32] ), .VDD_1p0( VDD_1p0 ), .VDD_2p5(
VDD_2p5 ), .OUT( adc_1p0[32] ), .VSS( vss ) ),
  I_adc_31 ( .IN( adc_2p5[31] ), .VDD_1p0( VDD_1p0 ), .VDD_2p5(
VDD_2p5 ), .OUT( adc_1p0[31] ), .VSS( vss ) ),
  I_adc_30 ( .IN( adc_2p5[30] ), .VDD_1p0( VDD_1p0 ), .VDD_2p5(
VDD_2p5 ), .OUT( adc_1p0[30] ), .VSS( vss ) ),
  I_adc_29 ( .IN( adc_2p5[29] ), .VDD_1p0( VDD_1p0 ), .VDD_2p5(
VDD_2p5 ), .OUT( adc_1p0[29] ), .VSS( vss ) ),
  I_adc_28 ( .IN( adc_2p5[28] ), .VDD_1p0( VDD_1p0 ), .VDD_2p5(
VDD_2p5 ), .OUT( adc_1p0[28] ), .VSS( vss ) ),
  I_adc_27 ( .IN( adc_2p5[27] ), .VDD_1p0( VDD_1p0 ), .VDD_2p5(
VDD_2p5 ), .OUT( adc_1p0[27] ), .VSS( vss ) ),
  I_adc_26 ( .IN( adc_2p5[26] ), .VDD_1p0( VDD_1p0 ), .VDD_2p5(
VDD_2p5 ), .OUT( adc_1p0[26] ), .VSS( vss ) ),
  I_adc_25 ( .IN( adc_2p5[25] ), .VDD_1p0( VDD_1p0 ), .VDD_2p5(
VDD_2p5 ), .OUT( adc_1p0[25] ), .VSS( vss ) ),
  I_adc_24 ( .IN( adc_2p5[24] ), .VDD_1p0( VDD_1p0 ), .VDD_2p5(
VDD_2p5 ), .OUT( adc_1p0[24] ), .VSS( vss ) ),
  I_adc_23 ( .IN( adc_2p5[23] ), .VDD_1p0( VDD_1p0 ), .VDD_2p5(
VDD_2p5 ), .OUT( adc_1p0[23] ), .VSS( vss ) ),
  I_adc_22 ( .IN( adc_2p5[22] ), .VDD_1p0( VDD_1p0 ), .VDD_2p5(
VDD_2p5 ), .OUT( adc_1p0[22] ), .VSS( vss ) ),
  I_adc_21 ( .IN( adc_2p5[21] ), .VDD_1p0( VDD_1p0 ), .VDD_2p5(
VDD_2p5 ), .OUT( adc_1p0[21] ), .VSS( vss ) ),
  I_adc_20 ( .IN( adc_2p5[20] ), .VDD_1p0( VDD_1p0 ), .VDD_2p5(
VDD_2p5 ), .OUT( adc_1p0[20] ), .VSS( vss ) ),
  I_adc_19 ( .IN( adc_2p5[19] ), .VDD_1p0( VDD_1p0 ), .VDD_2p5(
VDD_2p5 ), .OUT( adc_1p0[19] ), .VSS( vss ) ),
  I_adc_18 ( .IN( adc_2p5[18] ), .VDD_1p0( VDD_1p0 ), .VDD_2p5(
VDD_2p5 ), .OUT( adc_1p0[18] ), .VSS( vss ) ),
  I_adc_17 ( .IN( adc_2p5[17] ), .VDD_1p0( VDD_1p0 ), .VDD_2p5(
VDD_2p5 ), .OUT( adc_1p0[17] ), .VSS( vss ) ),
  I_adc_16 ( .IN( adc_2p5[16] ), .VDD_1p0( VDD_1p0 ), .VDD_2p5(
VDD_2p5 ), .OUT( adc_1p0[16] ), .VSS( vss ) ),
  I_adc_15 ( .IN( adc_2p5[15] ), .VDD_1p0( VDD_1p0 ), .VDD_2p5(
VDD_2p5 ), .OUT( adc_1p0[15] ), .VSS( vss ) ),
  I_adc_14 ( .IN( adc_2p5[14] ), .VDD_1p0( VDD_1p0 ), .VDD_2p5(
VDD_2p5 ), .OUT( adc_1p0[14] ), .VSS( vss ) ),
  I_adc_13 ( .IN( adc_2p5[13] ), .VDD_1p0( VDD_1p0 ), .VDD_2p5(
VDD_2p5 ), .OUT( adc_1p0[13] ), .VSS( vss ) ),
  I_adc_12 ( .IN( adc_2p5[12] ), .VDD_1p0( VDD_1p0 ), .VDD_2p5(
VDD_2p5 ), .OUT( adc_1p0[12] ), .VSS( vss ) ),
  I_adc_11 ( .IN( adc_2p5[11] ), .VDD_1p0( VDD_1p0 ), .VDD_2p5(
VDD_2p5 ), .OUT( adc_1p0[11] ), .VSS( vss ) ),
  I_adc_10 ( .IN( adc_2p5[10] ), .VDD_1p0( VDD_1p0 ), .VDD_2p5(
VDD_2p5 ), .OUT( adc_1p0[10] ), .VSS( vss ) ),
  I_adc_9 ( .IN( adc_2p5[9] ), .VDD_1p0( VDD_1p0 ), .VDD_2p5( VDD_2p5 ),
.OUT( adc_1p0[9] ), .VSS( vss ) ),
  I_adc_8 ( .IN( adc_2p5[8] ), .VDD_1p0( VDD_1p0 ), .VDD_2p5( VDD_2p5 ),
.OUT( adc_1p0[8] ), .VSS( vss ) ),
  I_adc_7 ( .IN( adc_2p5[7] ), .VDD_1p0( VDD_1p0 ), .VDD_2p5( VDD_2p5 ),
.OUT( adc_1p0[7] ), .VSS( vss ) ),
  I_adc_6 ( .IN( adc_2p5[6] ), .VDD_1p0( VDD_1p0 ), .VDD_2p5( VDD_2p5 ),
.OUT( adc_1p0[6] ), .VSS( vss ) ),
  I_adc_5 ( .IN( adc_2p5[5] ), .VDD_1p0( VDD_1p0 ), .VDD_2p5( VDD_2p5 ),
.OUT( adc_1p0[5] ), .VSS( vss ) ),
  I_adc_4 ( .IN( adc_2p5[4] ), .VDD_1p0( VDD_1p0 ), .VDD_2p5( VDD_2p5 ),
.OUT( adc_1p0[4] ), .VSS( vss ) ),
  I_adc_3 ( .IN( adc_2p5[3] ), .VDD_1p0( VDD_1p0 ), .VDD_2p5( VDD_2p5 ),
.OUT( adc_1p0[3] ), .VSS( vss ) ),
  I_adc_2 ( .IN( adc_2p5[2] ), .VDD_1p0( VDD_1p0 ), .VDD_2p5( VDD_2p5 ),
.OUT( adc_1p0[2] ), .VSS( vss ) ),
  I_adc_1 ( .IN( adc_2p5[1] ), .VDD_1p0( VDD_1p0 ), .VDD_2p5( VDD_2p5 ),
.OUT( adc_1p0[1] ), .VSS( vss ) ),
  I_adc_0 ( .IN( adc_2p5[0] ), .VDD_1p0( VDD_1p0 ), .VDD_2p5( VDD_2p5 ),
.OUT( adc_1p0[0] ), .VSS( vss ) );
level_shifter_2p5_1p0 #(.d2a_tr("200p"), .ieIO("output"), .d2a_tf("200p"),
 .d2a_vh("2.5")) (*
integer library_binding = "ether";
 *)
I_ph1 ( .IN(
ph1_2p5 ), .VDD_1p0( VDD_1p0 ), .VDD_2p5( VDD_2p5 ), .OUT( ph1_1p0 ),
.VSS( vss ) );
level_shifter_2p5_1p0 #(.d2a_tr("200p"), .ieIO("input"), .a2d_v0("0.5"),
 .d2a_tf("200p"), .a2d_tx("100p"), .d2a_vh("2.5"), .a2d_v1("0.8")) (*

integer library_binding = "ether";
integer elaboration_binding
 = "I_flash[5:0]";
 *)
I_flash_5 ( .IN( flash_2p5[5] ), .VDD_1p0(
VDD_1p0 ), .VDD_2p5( VDD_2p5 ), .OUT( flash_1p0[5] ), .VSS( vss ) ),
  I_flash_4 ( .IN( flash_2p5[4] ), .VDD_1p0( VDD_1p0 ), .VDD_2p5(
VDD_2p5 ), .OUT( flash_1p0[4] ), .VSS( vss ) ),
  I_flash_3 ( .IN( flash_2p5[3] ), .VDD_1p0( VDD_1p0 ), .VDD_2p5(
VDD_2p5 ), .OUT( flash_1p0[3] ), .VSS( vss ) ),
  I_flash_2 ( .IN( flash_2p5[2] ), .VDD_1p0( VDD_1p0 ), .VDD_2p5(
VDD_2p5 ), .OUT( flash_1p0[2] ), .VSS( vss ) ),
  I_flash_1 ( .IN( flash_2p5[1] ), .VDD_1p0( VDD_1p0 ), .VDD_2p5(
VDD_2p5 ), .OUT( flash_1p0[1] ), .VSS( vss ) ),
  I_flash_0 ( .IN( flash_2p5[0] ), .VDD_1p0( VDD_1p0 ), .VDD_2p5(
VDD_2p5 ), .OUT( flash_1p0[0] ), .VSS( vss ) );

endmodule
