// Verilog-AMS netlist generated by the AMS netlister, version ICOA5.2.51.500.7.
// Cadence Design Systems, Inc.

`include "disciplines.vams"

module adc_sample_hold ( outm,outp,SIDDQ,VDD,VSS,bias100,hold,
hold_test,inm,inm_test,inp,inp_test,sample,sample_test );

output   outm;
output   outp;
input   SIDDQ;
input   VDD;
input
 VSS;
input   bias100;
input   hold;
input   hold_test;
input   inm;

input   inm_test;
input   inp;
input   inp_test;
input   sample;

input   sample_test;

parameter rsw=1500;
parameter vgain=0.6;
parameter vcm=0.765;
parameter delay="(rsw*chold)";
parameter chold=2.5E-13;

inv_2x_hv (*
integer library_binding = "ether";
integer cds_net_set
[0:1] = { "DVSS","DVDD" };
integer DVSS = "VSS";
integer DVDD
 = "VDD";
 *)
I58 ( .Y( SIDDQb ), .A( SIDDQ ) );

gpdk090_nmos2v #(.ps(3.6u), .m(2 * 1), .as(900f), .l(280n), .pd(3.6u),
 .ad(900f), .w(3u)) (*
integer library_binding = "gpdk090";
integer
passed_mfactor = "m";
 *)
NM1 ( inm_test, sample_test, net0154, VSS );
gpdk090_nmos2v #(.ps(3.6u), .m(2 * 1), .as(900f), .l(280n), .pd(3.6u),
 .ad(900f), .w(3u)) (*
integer library_binding = "gpdk090";
integer
passed_mfactor = "m";
 *)
NM3 ( inp_test, sample_test, net58, VSS );
gpdk090_nmos2v #(.ps(3.6u), .m(1 * 1), .as(900f), .l(280n), .pd(3.6u),
 .ad(900f), .w(3u)) (*
integer library_binding = "gpdk090";
integer
passed_mfactor = "m";
 *)
NM14 ( net58, hold_test, net58, VSS );
gpdk090_nmos2v #(.ps(3.6u), .m(1 * 1), .as(900f), .l(280n), .pd(3.6u),
 .ad(900f), .w(3u)) (*
integer library_binding = "gpdk090";
integer
passed_mfactor = "m";
 *)
NM9 ( net58, hold, net58, VSS );
gpdk090_nmos2v #(.ps(3.6u), .m(2 * 1), .as(900f), .l(280n), .pd(3.6u),
 .ad(900f), .w(3u)) (*
integer library_binding = "gpdk090";
integer
passed_mfactor = "m";
 *)
NM12 ( net58, sample, inp, VSS );
gpdk090_nmos2v #(.ps(3.6u), .m(1 * 1), .as(900f), .l(280n), .pd(3.6u),
 .ad(900f), .w(3u)) (*
integer library_binding = "gpdk090";
integer
passed_mfactor = "m";
 *)
NM16 ( net0154, hold_test, net0154, VSS );
gpdk090_nmos2v #(.ps(3.6u), .m(2 * 1), .as(900f), .l(280n), .pd(3.6u),
 .ad(900f), .w(3u)) (*
integer library_binding = "gpdk090";
integer
passed_mfactor = "m";
 *)
NM0 ( net0154, sample, inm, VSS );
gpdk090_nmos2v #(.ps(3.6u), .m(1 * 1), .as(900f), .l(280n), .pd(3.6u),
 .ad(900f), .w(3u)) (*
integer library_binding = "gpdk090";
integer
passed_mfactor = "m";
 *)
NM2 ( net0154, hold, net0154, VSS );
gpdk090_nmos2v #(.ps(1.8u), .m(1 * 1), .as(360f), .l(280n), .pd(1.8u),
 .ad(360f), .w(1.2u)) (*
integer library_binding = "gpdk090";
integer
passed_mfactor = "m";
 *)
NM8 ( bias100, SIDDQ, VSS, VSS );
gpdk090_nmos2v #(.ps(5.48u), .m(2 * 4), .as(2.4p), .l(1u), .pd(360n),
.ad(1.8p), .w(10u)) (*
integer library_binding = "gpdk090";
integer
passed_mfactor = "m";
 *)
NM4 ( bias1, bias100, VSS, VSS );
gpdk090_nmos2v #(.ps(1.8u), .m(1 * 1), .as(360f), .l(280n), .pd(1.8u),
 .ad(360f), .w(1.2u)) (*
integer library_binding = "gpdk090";
integer
passed_mfactor = "m";
 *)
NM6 ( net0154, SIDDQ, VSS, VSS );
gpdk090_nmos2v #(.ps(1.8u), .m(1 * 1), .as(360f), .l(280n), .pd(1.8u),
 .ad(360f), .w(1.2u)) (*
integer library_binding = "gpdk090";
integer
passed_mfactor = "m";
 *)
NM10 ( outp, SIDDQ, VSS, VSS );
gpdk090_nmos2v #(.ps(1.8u), .m(1 * 1), .as(360f), .l(280n), .pd(1.8u),
 .ad(360f), .w(1.2u)) (*
integer library_binding = "gpdk090";
integer
passed_mfactor = "m";
 *)
NM7 ( outm, SIDDQ, VSS, VSS );
gpdk090_nmos2v #(.ps(10.6u), .m(1 * 2), .as(3p), .l(1u), .pd(360n), .ad(1.8p),
 .w(10u)) (*
integer library_binding = "gpdk090";
integer
passed_mfactor = "m";
 *)
NM5 ( bias100, bias100, VSS, VSS );
gpdk090_nmos2v #(.ps(1.8u), .m(1 * 1), .as(360f), .l(280n), .pd(1.8u),
 .ad(360f), .w(1.2u)) (*
integer library_binding = "gpdk090";
integer
passed_mfactor = "m";
 *)
NM11 ( net58, SIDDQ, VSS, VSS );

gpdk090_pmos2v #(.ps(4.408u), .m(2 * 10), .as(4.08p), .l(280n), .pd(360n),
 .ad(3.6p), .w(20u)) (*
integer library_binding = "gpdk090";
integer
passed_mfactor = "m";
 *)
PM4 ( VSS, net58, outp, outp );
gpdk090_pmos2v #(.ps(4.408u), .m(2 * 10), .as(4.08p), .l(280n), .pd(360n),
 .ad(3.6p), .w(20u)) (*
integer library_binding = "gpdk090";
integer
passed_mfactor = "m";
 *)
PM0 ( VSS, net0154, outm, outm );
gpdk090_pmos2v #(.ps(20.6u), .m(10 * 2), .as(6p), .l(500n), .pd(360n),
 .ad(3.6p), .w(20u)) (*
integer library_binding = "gpdk090";
integer
passed_mfactor = "m";
 *)
PM3 ( outp, bias1, VDD, VDD );
gpdk090_pmos2v #(.ps(20.6u), .m(10 * 2), .as(6p), .l(500n), .pd(360n),
 .ad(3.6p), .w(20u)) (*
integer library_binding = "gpdk090";
integer
passed_mfactor = "m";
 *)
PM1 ( outm, bias1, VDD, VDD );
gpdk090_pmos2v #(.ps(20.6u), .m(4 * 2), .as(6p), .l(500n), .pd(360n),
.ad(3.6p), .w(20u)) (*
integer library_binding = "gpdk090";
integer
passed_mfactor = "m";
 *)
PM6 ( bias1, bias1, VDD, VDD );
gpdk090_pmos2v #(.ps(1.8u), .m(1 * 1), .as(360f), .l(280n), .pd(1.8u),
 .ad(360f), .w(1.2u)) (*
integer library_binding = "gpdk090";
integer
passed_mfactor = "m";
 *)
PM2 ( bias1, SIDDQb, VDD, VDD );

gpdk090_pmoscap2v #(.m(2 * 1), .l(7.2u), .w(6.755u)) (*
integer
library_binding = "gpdk090";
integer passed_mfactor = "m";
 *)
C4 (
VDD, net58, VDD, VDD );
gpdk090_pmoscap2v #(.m(2 * 1), .l(7.2u), .w(6.755u)) (*
integer
library_binding = "gpdk090";
integer passed_mfactor = "m";
 *)
C3 (
VDD, net0154, VDD, VDD );

endmodule
