// Verilog-AMS netlist generated by the AMS netlister, version ICOA5.2.51.500.7.
// Cadence Design Systems, Inc.

`include "disciplines.vams"

module adc_IREF_bias ( pbias,SIDDQ,VDD,Iin1,pbias_cas,Iin2,VSS );

output   pbias;
input   SIDDQ;
input   VDD;
input   Iin1;
output
 pbias_cas;
input   Iin2;
input   VSS;

gpdk090_pmos2v #(.ps(41.2u), .m(1 * 2), .as(12p), .l(500n), .pd(20.6u),
 .ad(6p), .w(20u)) (*
integer library_binding = "gpdk090";
integer
passed_mfactor = "m";
 *)
PM35 ( net0165, pbias_cas, VDD, VDD );
gpdk090_pmos2v #(.ps(30.9u), .m(2 * 4), .as(9p), .l(2.5u), .pd(20.6u),
 .ad(6p), .w(20u)) (*
integer library_binding = "gpdk090";
integer
passed_mfactor = "m";
 *)
PM2 ( net13, pbias, VDD, VDD );
gpdk090_pmos2v #(.ps(41.2u), .m(2 * 2), .as(12p), .l(1u), .pd(20.6u),
.ad(6p), .w(20u)) (*
integer library_binding = "gpdk090";
integer
passed_mfactor = "m";
 *)
PM6 ( pbias, pbias_cas, net13, net13 );
gpdk090_pmos2v #(.ps(38.4u), .m(1 * 4), .as(11.25p), .l(280.0n), .pd(25.6u),
 .ad(7.5p), .w(25u)) (*
integer library_binding = "gpdk090";
integer
passed_mfactor = "m";
 *)
PM49 ( net80, SIDDQ, Iin2, VDD );
gpdk090_pmos2v #(.ps(3.2u), .m(1 * 1), .as(600f), .l(280.0n), .pd(3.2u),
 .ad(600f), .w(1u)) (*
integer library_binding = "gpdk090";
integer
passed_mfactor = "m";
 *)
PM51 ( net20, SIDDQb, VDD, VDD );
gpdk090_pmos2v #(.ps(38.4u), .m(1 * 4), .as(11.25p), .l(280.0n), .pd(25.6u),
 .ad(7.5p), .w(25u)) (*
integer library_binding = "gpdk090";
integer
passed_mfactor = "m";
 *)
PM50 ( net20, SIDDQ, Iin1, VDD );
gpdk090_pmos2v #(.ps(41.2u), .m(1 * 2), .as(12p), .l(500n), .pd(20.6u),
 .ad(6p), .w(20u)) (*
integer library_binding = "gpdk090";
integer
passed_mfactor = "m";
 *)
PM7 ( pbias_cas, pbias_cas, net0157, VDD );
gpdk090_pmos2v #(.ps(3.2u), .m(1 * 1), .as(600f), .l(280.0n), .pd(3.2u),
 .ad(600f), .w(1u)) (*
integer library_binding = "gpdk090";
integer
passed_mfactor = "m";
 *)
PM34 ( pbias_cas, SIDDQb, VDD, VDD );
gpdk090_pmos2v #(.ps(41.2u), .m(1 * 2), .as(12p), .l(500n), .pd(20.6u),
 .ad(6p), .w(20u)) (*
integer library_binding = "gpdk090";
integer
passed_mfactor = "m";
 *)
PM9 ( net0173, pbias_cas, net0165, VDD );
gpdk090_pmos2v #(.ps(41.2u), .m(1 * 2), .as(12p), .l(500n), .pd(20.6u),
 .ad(6p), .w(20u)) (*
integer library_binding = "gpdk090";
integer
passed_mfactor = "m";
 *)
PM5 ( net0157, pbias_cas, net0175, VDD );
gpdk090_pmos2v #(.ps(41.2u), .m(1 * 2), .as(12p), .l(500n), .pd(20.6u),
 .ad(6p), .w(20u)) (*
integer library_binding = "gpdk090";
integer
passed_mfactor = "m";
 *)
PM8 ( net0175, pbias_cas, net0173, VDD );

gpdk090_nmos2v #(.ps(15.9u), .m(1 * 4), .as(4.5p), .l(1u), .pd(10.6u),
 .ad(3p), .w(10u)) (*
integer library_binding = "gpdk090";
integer
passed_mfactor = "m";
 *)
NM5 ( net20, net80, net92, VSS );
gpdk090_nmos2v #(.ps(3.2u), .m(1 * 1), .as(600f), .l(280.0n), .pd(3.2u),
 .ad(600f), .w(1u)) (*
integer library_binding = "gpdk090";
integer
passed_mfactor = "m";
 *)
NM23 ( net80, SIDDQ, VSS, VSS );
gpdk090_nmos2v #(.ps(3.2u), .m(1 * 1), .as(600f), .l(280.0n), .pd(3.2u),
 .ad(600f), .w(1u)) (*
integer library_binding = "gpdk090";
integer
passed_mfactor = "m";
 *)
NM28 ( pbias, SIDDQ, VSS, VSS );
gpdk090_nmos2v #(.ps(15.9u), .m(1 * 4), .as(4.5p), .l(2.5u), .pd(10.6u),
 .ad(3p), .w(10u)) (*
integer library_binding = "gpdk090";
integer
passed_mfactor = "m";
 *)
NM14 ( net60, net20, VSS, VSS );
gpdk090_nmos2v #(.ps(38.4u), .m(1 * 4), .as(11.25p), .l(1u), .pd(25.6u),
 .ad(7.5p), .w(25u)) (*
integer library_binding = "gpdk090";
integer
passed_mfactor = "m";
 *)
NM15 ( pbias, net80, net60, VSS );
gpdk090_nmos2v #(.ps(41.2u), .m(1 * 1), .as(12p), .l(1u), .pd(41.2u),
.ad(12p), .w(20u)) (*
integer library_binding = "gpdk090";
integer
passed_mfactor = "m";
 *)
NM11 ( net0104, net80, net0108, VSS );
gpdk090_nmos2v #(.ps(41.2u), .m(1 * 1), .as(12p), .l(1u), .pd(41.2u),
.ad(12p), .w(20u)) (*
integer library_binding = "gpdk090";
integer
passed_mfactor = "m";
 *)
NM12 ( net0108, net80, net0112, VSS );
gpdk090_nmos2v #(.ps(41.2u), .m(1 * 1), .as(12p), .l(1u), .pd(41.2u),
.ad(12p), .w(20u)) (*
integer library_binding = "gpdk090";
integer
passed_mfactor = "m";
 *)
NM13 ( net0112, net80, VSS, VSS );
gpdk090_nmos2v #(.ps(41.2u), .m(1 * 1), .as(12p), .l(1u), .pd(41.2u),
.ad(12p), .w(20u)) (*
integer library_binding = "gpdk090";
integer
passed_mfactor = "m";
 *)
NM16 ( net80, net80, net0113, VSS );
gpdk090_nmos2v #(.ps(41.2u), .m(1 * 1), .as(12p), .l(1u), .pd(41.2u),
.ad(12p), .w(20u)) (*
integer library_binding = "gpdk090";
integer
passed_mfactor = "m";
 *)
NM18 ( net0113, net80, net0104, VSS );
gpdk090_nmos2v #(.ps(15.9u), .m(1 * 4), .as(4.5p), .l(2.5u), .pd(10.6u),
 .ad(3p), .w(10u)) (*
integer library_binding = "gpdk090";
integer
passed_mfactor = "m";
 *)
NM10 ( net92, net20, VSS, VSS );
gpdk090_nmos2v #(.ps(15.9u), .m(1 * 4), .as(4.5p), .l(2.5u), .pd(10.6u),
 .ad(3p), .w(10u)) (*
integer library_binding = "gpdk090";
integer
passed_mfactor = "m";
 *)
NM17 ( net96, net20, VSS, VSS );
gpdk090_nmos2v #(.ps(15.9u), .m(1 * 4), .as(4.5p), .l(1u), .pd(10.6u),
 .ad(3p), .w(10u)) (*
integer library_binding = "gpdk090";
integer
passed_mfactor = "m";
 *)
NM21 ( pbias_cas, net80, net96, VSS );

gpdk090_nmoscap2v #(.m(1 * 1), .l(17.5u), .w(33.005u)) (*
integer
library_binding = "gpdk090";
integer passed_mfactor = "m";
 *)
C1 (
VSS, net20, VSS, VSS );
gpdk090_nmoscap2v #(.m(1 * 1), .l(17.5u), .w(33.005u)) (*
integer
library_binding = "gpdk090";
integer passed_mfactor = "m";
 *)
C2 (
VSS, net20, VSS, VSS );
gpdk090_nmoscap2v #(.m(1 * 1), .l(14u), .w(35.365u)) (*
integer
library_binding = "gpdk090";
integer passed_mfactor = "m";
 *)
C0 (
VSS, net20, VSS, VSS );

inv_2x_hv (*
integer library_binding = "ether";
integer cds_net_set
[0:1] = { "DVSS","DVDD" };
integer DVSS = "VSS";
integer DVDD
 = "VDD";
 *)
I1 ( .Y( SIDDQb ), .A( SIDDQ ) );

endmodule
