// Verilog-AMS netlist generated by the AMS netlister, version ICOA5.2.51.500.7.
// Cadence Design Systems, Inc.

`include "disciplines.vams"

module trans_ld_tenbt_driver ( gnd,vdd,pbias1,neg_out,pos_out,siddq,
MAN_ENC,pbias2 );

input   gnd;
input   vdd;
input   pbias1;
output   neg_out;
output
 pos_out;
input   siddq;
input   MAN_ENC;
input   pbias2;

trans_ld_tenbt_vi_conv (*
integer library_binding = "ether";
 *)
I62
 ( .out_neg( net27 ), .out_pos( net95 ), .gnd( gnd ), .vdd( vdd ), .pbias1(
pbias1 ), .siddq( siddq ), .MAN_ENC( MAN_ENC ), .pbias2( pbias2 ) );

trans_ld_tenbt_current_mirror (*
integer library_binding = "ether";

 *)
I25 ( .pos_in( net95 ), .neg_in( net27 ), .gnd( gnd ), .neg_out(
neg_out ), .VDD( vdd ), .pos_out( pos_out ), .siddq( siddq ) );

endmodule
