// Verilog-AMS netlist generated by the AMS netlister, version ICOA5.2.51.500.7.
// Cadence Design Systems, Inc.

`include "disciplines.vams"

module pi_dig_phase ( RCLK125,ADC_TEST_MODE,CLK250_TAPS,PHASE_DN,
PHASE_UP,RCLK125_TEST,RESET );

output   RCLK125;
input   ADC_TEST_MODE;
input [21:0]  CLK250_TAPS;

input   PHASE_DN;
input   PHASE_UP;
input   RCLK125_TEST;
input
 RESET;

wire n_83;
wire prev2_reset;
wire n_56;
wire n_25;
wire n_100;
wire n_114;
wire n_87;
wire n_89;
wire n_88;
wire RESET;
wire n_112;
wire n_90;
wire n_10;
wire n_96;
wire prev1_reset;
wire [4:0] curr_tap;
wire prev_phase_up;
wire n_373;
wire n_79;
wire tie_hi;
wire rclk250_div2;
wire n_99;
wire upd_enab;
wire n_94;
wire n_49;
wire n_109;
wire n_101;
wire mux_reset;
wire n_80;
wire n_102;
wire n_39;
wire n_47;
wire PHASE_UP;
wire n_17;
wire n_81;
wire [4:0] new_tap;
wire n_37;
wire n_104;
wire n_93;
wire [21:0] CLK250_TAPS;
wire prev_phase_down;
wire n_376;
wire n_375;
wire n_84;
wire n_82;
wire n_103;
wire rclk250;
wire RCLK125;
wire \nbus_26[0] ;
wire n_78;
wire tie_lo;
wire n_61;
wire n_86;
wire [4:0] nbus_27;
wire PHASE_DN;
wire n_374;
wire n_108;
wire n_52;
wire n_75;
wire RCLK125_TEST;
wire n_18;
wire ADC_TEST_MODE;
wire n_63;

AWMUX_32_1_0 (*
integer library_binding = "ether";
 *)
i_123 ( .I28(
net626 ), .I19( CLK250_TAPS[19] ), .I20( CLK250_TAPS[20] ), .I8(
CLK250_TAPS[8] ), .I11( CLK250_TAPS[11] ), .I30( net628 ), .O0(
rclk250 ), .I14( CLK250_TAPS[14] ), .I21( CLK250_TAPS[21] ), .I9(
CLK250_TAPS[9] ), .I22( net620 ), .I3( CLK250_TAPS[3] ), .I18(
CLK250_TAPS[18] ), .I10( CLK250_TAPS[10] ), .I0( CLK250_TAPS[0] ), .I12(
CLK250_TAPS[12] ), .S( curr_tap[4:0] ), .I16( CLK250_TAPS[16] ), .I27(
net625 ), .I2( CLK250_TAPS[2] ), .I7( CLK250_TAPS[7] ), .I17(
CLK250_TAPS[17] ), .I29( net627 ), .I1( CLK250_TAPS[1] ), .I24( net622 ),
.I31( net629 ), .I13( CLK250_TAPS[13] ), .I23( net621 ), .I26( net624 ),
.I5( CLK250_TAPS[5] ), .I4( CLK250_TAPS[4] ), .I25( net623 ), .I15(
CLK250_TAPS[15] ), .I6( CLK250_TAPS[6] ) );

AWMUX_32_1_1 (*
integer library_binding = "ether";
 *)
i_6 ( .I28(
net660 ), .I19( CLK250_TAPS[19] ), .I20( CLK250_TAPS[20] ), .I8(
CLK250_TAPS[8] ), .I11( CLK250_TAPS[11] ), .I30( net662 ), .O0( n_83 ),
.I14( CLK250_TAPS[14] ), .I21( CLK250_TAPS[21] ), .I9( CLK250_TAPS[9] ),
.I22( net654 ), .I3( CLK250_TAPS[3] ), .I18( CLK250_TAPS[18] ), .I10(
CLK250_TAPS[10] ), .I0( CLK250_TAPS[0] ), .I12( CLK250_TAPS[12] ), .S(
new_tap[4:0] ), .I16( CLK250_TAPS[16] ), .I27( net659 ), .I2(
CLK250_TAPS[2] ), .I7( CLK250_TAPS[7] ), .I17( CLK250_TAPS[17] ), .I29(
net661 ), .I1( CLK250_TAPS[1] ), .I24( net656 ), .I31( net663 ), .I13(
CLK250_TAPS[13] ), .I23( net655 ), .I26( net658 ), .I5( CLK250_TAPS[5] ),
.I4( CLK250_TAPS[4] ), .I25( net657 ), .I15( CLK250_TAPS[15] ), .I6(
CLK250_TAPS[6] ) );

INVX1 (*
integer library_binding = "gsclib090";
 *)
i_250 ( .Y( n_373 ),
.A( nbus_27[3] ) );
INVX1 (*
integer library_binding = "gsclib090";
 *)
i_251 ( .Y( n_374 ),
.A( n_83 ) );
INVX1 (*
integer library_binding = "gsclib090";
 *)
i_252 ( .Y( n_376 ),
.A( RESET ) );

DFFX1 (*
integer library_binding = "gsclib090";
 *)
rclk250_div2_reg
 ( .QN( n_25 ), .D( n_25 ), .CK( rclk250 ), .Q( rclk250_div2 ) );

MX2X1 (*
integer library_binding = "gsclib090";
 *)
i_125 ( .Y(
RCLK125 ), .S0( ADC_TEST_MODE ), .B( RCLK125_TEST ), .A( rclk250_div2 ) );

AND2X1 (*
integer library_binding = "gsclib090";
 *)
i_14 ( .Y( n_10 ),
.B( prev_phase_up ), .A( PHASE_UP ) );
AND2X1 (*
integer library_binding = "gsclib090";
 *)
i_10 ( .Y( n_17 ),
.B( prev_phase_down ), .A( PHASE_DN ) );

SDFFSRX1 (*
integer library_binding = "gsclib090";
 *)
new_tap_reg_0
 ( .QN( net765 ), .D( new_tap[0] ), .SI( nbus_27[0] ), .RN( n_375 ), .SN(
tie_hi ), .CK( rclk250 ), .SE( \nbus_26[0]  ), .Q( new_tap[0] ) );
SDFFSRX1 (*
integer library_binding = "gsclib090";
 *)
new_tap_reg_1
 ( .QN( net757 ), .D( new_tap[1] ), .SI( nbus_27[1] ), .RN( n_375 ), .SN(
tie_hi ), .CK( rclk250 ), .SE( \nbus_26[0]  ), .Q( new_tap[1] ) );
SDFFSRX1 (*
integer library_binding = "gsclib090";
 *)
new_tap_reg_2
 ( .QN( net749 ), .D( new_tap[2] ), .SI( nbus_27[2] ), .RN( n_375 ), .SN(
tie_hi ), .CK( rclk250 ), .SE( \nbus_26[0]  ), .Q( new_tap[2] ) );
SDFFSRX1 (*
integer library_binding = "gsclib090";
 *)
new_tap_reg_3
 ( .QN( net741 ), .D( new_tap[3] ), .SI( n_373 ), .RN( n_375 ), .SN(
tie_hi ), .CK( rclk250 ), .SE( \nbus_26[0]  ), .Q( new_tap[3] ) );
SDFFSRX1 (*
integer library_binding = "gsclib090";
 *)
new_tap_reg_4
 ( .QN( net733 ), .D( new_tap[4] ), .SI( nbus_27[4] ), .RN( n_375 ), .SN(
tie_hi ), .CK( rclk250 ), .SE( \nbus_26[0]  ), .Q( new_tap[4] ) );
SDFFSRX1 (*
integer library_binding = "gsclib090";
 *)
curr_tap_reg_0
 ( .QN( nbus_27[0] ), .D( curr_tap[0] ), .SI( new_tap[0] ), .RN( n_375 ),
.SN( tie_hi ), .CK( n_374 ), .SE( upd_enab ), .Q( curr_tap[0] ) );
SDFFSRX1 (*
integer library_binding = "gsclib090";
 *)
curr_tap_reg_1
 ( .QN( n_39 ), .D( curr_tap[1] ), .SI( new_tap[1] ), .RN( n_375 ), .SN(
tie_hi ), .CK( n_374 ), .SE( upd_enab ), .Q( curr_tap[1] ) );
SDFFSRX1 (*
integer library_binding = "gsclib090";
 *)
curr_tap_reg_3
 ( .QN( net709 ), .D( curr_tap[3] ), .SI( new_tap[3] ), .RN( n_375 ),
.SN( tie_hi ), .CK( n_374 ), .SE( upd_enab ), .Q( curr_tap[3] ) );
SDFFSRX1 (*
integer library_binding = "gsclib090";
 *)
curr_tap_reg_4
 ( .QN( net701 ), .D( curr_tap[4] ), .SI( new_tap[4] ), .RN( n_375 ),
.SN( tie_hi ), .CK( n_374 ), .SE( upd_enab ), .Q( curr_tap[4] ) );
SDFFSRX1 (*
integer library_binding = "gsclib090";
 *)
curr_tap_reg_2
 ( .QN( n_37 ), .D( curr_tap[2] ), .SI( new_tap[2] ), .RN( n_375 ), .SN(
tie_hi ), .CK( n_374 ), .SE( upd_enab ), .Q( curr_tap[2] ) );

DFFSRX1 (*
integer library_binding = "gsclib090";
 *)
prev1_reset_reg
 ( .QN( net795 ), .D( tie_lo ), .RN( tie_hi ), .SN( n_376 ), .CK(
rclk250 ), .Q( prev1_reset ) );
DFFSRX1 (*
integer library_binding = "gsclib090";
 *)
prev2_reset_reg
 ( .QN( net789 ), .D( prev1_reset ), .RN( tie_hi ), .SN( n_376 ), .CK(
rclk250 ), .Q( prev2_reset ) );
DFFSRX1 (*
integer library_binding = "gsclib090";
 *)
mux_reset_reg (
.QN( n_375 ), .D( prev2_reset ), .RN( tie_hi ), .SN( n_376 ), .CK(
rclk250 ), .Q( mux_reset ) );
DFFSRX1 (*
integer library_binding = "gsclib090";
 *)

prev_phase_up_reg ( .QN( prev_phase_up ), .D( PHASE_UP ), .RN( n_375 ),
.SN( tie_hi ), .CK( rclk250 ), .Q( net775 ) );
DFFSRX1 (*
integer library_binding = "gsclib090";
 *)

prev_phase_down_reg ( .QN( prev_phase_down ), .D( PHASE_DN ), .RN(
n_375 ), .SN( tie_hi ), .CK( rclk250 ), .Q( net769 ) );

OAI21X1 (*
integer library_binding = "gsclib090";
 *)
i_3335 ( .A0(
curr_tap[4] ), .A1( n_84 ), .B0( n_103 ), .Y( n_102 ) );
OAI21X1 (*
integer library_binding = "gsclib090";
 *)
i_18 ( .A0(
curr_tap[3] ), .A1( n_90 ), .B0( n_52 ), .Y( n_109 ) );
OAI21X1 (*
integer library_binding = "gsclib090";
 *)
i_19 ( .A0(
curr_tap[4] ), .A1( n_94 ), .B0( n_47 ), .Y( n_112 ) );
OAI21X1 (*
integer library_binding = "gsclib090";
 *)
i_3542 ( .A0(
n_10 ), .A1( n_99 ), .B0( n_63 ), .Y( nbus_27[1] ) );
OAI21X1 (*
integer library_binding = "gsclib090";
 *)
i_3441 ( .A0(
n_10 ), .A1( n_101 ), .B0( n_61 ), .Y( nbus_27[2] ) );
OAI21X1 (*
integer library_binding = "gsclib090";
 *)
i_3239 ( .A0(
n_104 ), .A1( n_10 ), .B0( n_49 ), .Y( nbus_27[4] ) );

AOI21X1 (*
integer library_binding = "gsclib090";
 *)
i_42 ( .A0(
curr_tap[0] ), .A1( curr_tap[1] ), .B0( n_89 ), .Y( n_100 ) );
AOI21X1 (*
integer library_binding = "gsclib090";
 *)
i_45 ( .A0(
curr_tap[4] ), .A1( n_84 ), .B0( n_18 ), .Y( n_104 ) );
AOI21X1 (*
integer library_binding = "gsclib090";
 *)
i_3340 ( .A0(
n_10 ), .A1( n_109 ), .B0( n_56 ), .Y( nbus_27[3] ) );

NAND4X1 (*
integer library_binding = "gsclib090";
 *)
i_849 ( .D(
curr_tap[1] ), .C( curr_tap[3] ), .Y( n_94 ), .B( curr_tap[2] ), .A(
curr_tap[0] ) );
NAND4X1 (*
integer library_binding = "gsclib090";
 *)
i_16 ( .D( n_39 ),
.C( n_96 ), .Y( n_114 ), .B( curr_tap[4] ), .A( curr_tap[0] ) );

XOR2X1 (*
integer library_binding = "gsclib090";
 *)
i_9 ( .Y( n_78 ),
.B( curr_tap[4] ), .A( new_tap[4] ) );
XOR2X1 (*
integer library_binding = "gsclib090";
 *)
i_8 ( .Y( n_79 ),
.B( curr_tap[3] ), .A( new_tap[3] ) );
XOR2X1 (*
integer library_binding = "gsclib090";
 *)
i_762 ( .Y( n_80 ),
.B( curr_tap[2] ), .A( new_tap[2] ) );
XOR2X1 (*
integer library_binding = "gsclib090";
 *)
i_661 ( .Y( n_81 ),
.B( curr_tap[1] ), .A( new_tap[1] ) );
XOR2X1 (*
integer library_binding = "gsclib090";
 *)
i_5 ( .Y( n_82 ),
.B( curr_tap[0] ), .A( new_tap[0] ) );
XOR2X1 (*
integer library_binding = "gsclib090";
 *)
i_43 ( .Y( n_101 ),
.B( n_89 ), .A( n_37 ) );
XOR2X1 (*
integer library_binding = "gsclib090";
 *)
i_44 ( .Y( n_103 ),
.B( n_86 ), .A( curr_tap[3] ) );
XOR2X1 (*
integer library_binding = "gsclib090";
 *)
i_17 ( .Y( n_108 ),
.B( n_93 ), .A( n_37 ) );

OR4X1 (*
integer library_binding = "gsclib090";
 *)
i_1465 ( .D( n_79 ),
.C( n_80 ), .Y( n_75 ), .B( n_81 ), .A( n_82 ) );

OR2X1 (*
integer library_binding = "gsclib090";
 *)
i_1666 ( .Y(
upd_enab ), .B( n_75 ), .A( n_78 ) );
OR2X1 (*
integer library_binding = "gsclib090";
 *)
i_3537 ( .Y( n_99 ),
.B( n_100 ), .A( n_18 ) );
OR2X1 (*
integer library_binding = "gsclib090";
 *)
i_142 ( .Y(
\nbus_26[0]  ), .B( n_10 ), .A( n_17 ) );

NAND2X1 (*
integer library_binding = "gsclib090";
 *)
i_46 ( .Y( n_52 ),
.B( n_90 ), .A( curr_tap[3] ) );
NAND2X1 (*
integer library_binding = "gsclib090";
 *)
i_51 ( .Y( n_47 ),
.B( n_94 ), .A( curr_tap[4] ) );
NAND2X1 (*
integer library_binding = "gsclib090";
 *)
i_3255 ( .Y(
n_84 ), .B( n_87 ), .A( n_89 ) );
NAND2X1 (*
integer library_binding = "gsclib090";
 *)
i_23 ( .Y( n_88 ),
.B( n_37 ), .A( n_39 ) );
NAND2X1 (*
integer library_binding = "gsclib090";
 *)
i_148 ( .Y( n_93 ),
.B( curr_tap[1] ), .A( curr_tap[0] ) );

NOR2X1 (*
integer library_binding = "gsclib090";
 *)
i_38 ( .Y( n_56 ),
.B( n_102 ), .A( n_10 ) );
NOR2X1 (*
integer library_binding = "gsclib090";
 *)
i_31 ( .Y( n_86 ),
.B( n_88 ), .A( curr_tap[0] ) );
NOR2X1 (*
integer library_binding = "gsclib090";
 *)
i_24 ( .Y( n_87 ),
.B( curr_tap[2] ), .A( curr_tap[3] ) );
NOR2X1 (*
integer library_binding = "gsclib090";
 *)
i_1152 ( .Y( n_89 ),
.B( curr_tap[1] ), .A( curr_tap[0] ) );
NOR2X1 (*
integer library_binding = "gsclib090";
 *)
i_1244 ( .Y( n_96 ),
.B( n_37 ), .A( curr_tap[3] ) );
NOR2X1 (*
integer library_binding = "gsclib090";
 *)
i_1654 ( .Y( n_18 ),
.B( n_84 ), .A( curr_tap[4] ) );

NAND3X1 (*
integer library_binding = "gsclib090";
 *)
i_27 ( .C( n_10 ),
.Y( n_63 ), .B( n_100 ), .A( n_114 ) );
NAND3X1 (*
integer library_binding = "gsclib090";
 *)
i_29 ( .C( n_108 ),
.Y( n_61 ), .B( n_10 ), .A( n_114 ) );
NAND3X1 (*
integer library_binding = "gsclib090";
 *)
i_49 ( .C( n_112 ),
.Y( n_49 ), .B( n_10 ), .A( n_114 ) );
NAND3X1 (*
integer library_binding = "gsclib090";
 *)
i_7 ( .C(
curr_tap[2] ), .Y( n_90 ), .B( curr_tap[1] ), .A( curr_tap[0] ) );

TIELO (*
integer library_binding = "gsclib090";
 *)
i_TIELO ( .Y(
tie_lo ) );

TIEHI (*
integer library_binding = "gsclib090";
 *)
i_TIEHI ( .Y(
tie_hi ) );

endmodule
