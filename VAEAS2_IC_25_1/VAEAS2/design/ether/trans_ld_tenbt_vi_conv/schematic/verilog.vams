// Verilog-AMS netlist generated by the AMS netlister, version ICOA5.2.51.500.7.
// Cadence Design Systems, Inc.

`include "disciplines.vams"

module trans_ld_tenbt_vi_conv ( out_neg,out_pos,gnd,vdd,pbias1,siddq,
MAN_ENC,pbias2 );

output   out_neg;
output   out_pos;
input   gnd;
input   vdd;
input
 pbias1;
input   siddq;
input   MAN_ENC;
input   pbias2;

gpdk090_nmos2v #(.ps(36.2u), .m(1 * 1), .as(10.5p), .l(280.0n), .pd(36.2u),
 .ad(10.5p), .w(17.5u)) (*
integer library_binding = "gpdk090";

integer passed_mfactor = "m";
 *)
NM19 ( net21, a, out_neg, gnd );
gpdk090_nmos2v #(.ps(36.2u), .m(1 * 1), .as(10.5p), .l(280.0n), .pd(36.2u),
 .ad(10.5p), .w(17.5u)) (*
integer library_binding = "gpdk090";

integer passed_mfactor = "m";
 *)
NM20 ( net21, b, out_pos, gnd );
gpdk090_nmos2v #(.ps(21.2u), .m(1 * 1), .as(6p), .l(1u), .pd(21.2u), .ad(6p),
 .w(10u)) (*
integer library_binding = "gpdk090";
integer
passed_mfactor = "m";
 *)
NM21 ( net21, siddq, gnd, gnd );

gpdk090_pmos2v #(.ps(20.8421u), .m(1 * 19), .as(6.06316p), .l(400n), .pd(20.8421u),
 .ad(6.06316p), .w(19.2u)) (*
integer library_binding = "gpdk090";

integer passed_mfactor = "m";
 *)
PM5 ( net21, pbias2, net26, net26 );
gpdk090_pmos2v #(.ps(11.1579u), .m(1 * 19), .as(3.15789p), .l(1u), .pd(11.1579u),
 .ad(3.15789p), .w(10u)) (*
integer library_binding = "gpdk090";

integer passed_mfactor = "m";
 *)
PM15 ( net26, pbias1, vdd, vdd );

trans_ld_100tx_invequal (*
integer library_binding = "ether";
 *)
I0
 ( .out_inv( b ), .VDD( vdd ), .in( MAN_ENC ), .out( a ), .VSS( gnd ) );

endmodule
