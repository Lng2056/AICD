// Verilog-AMS netlist generated by the AMS netlister, version ICOA5.2.51.500.7.
// Cadence Design Systems, Inc.

`include "disciplines.vams"

module PLL_VCO_INV250 ( VDD,Y,VSS,A );

input   VDD;
inout   Y;
input   VSS;
input   A;

gpdk090_pmos2v #(.ps(4.2u), .m(1 * 2), .as(900f), .l(280.0n), .pd(2.1u),
 .ad(450f), .w(1.5u)) (*
integer library_binding = "gpdk090";
integer
passed_mfactor = "m";
 *)
PM0 ( Y, A, VDD, VDD );

gpdk090_nmos2v #(.ps(2.7u), .m(1 * 2), .as(450f), .l(280.0n), .pd(1.35u),
 .ad(225f), .w(750n)) (*
integer library_binding = "gpdk090";
integer
passed_mfactor = "m";
 *)
NM0 ( Y, A, VSS, VSS );

endmodule
