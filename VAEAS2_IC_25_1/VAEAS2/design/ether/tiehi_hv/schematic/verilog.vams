// Verilog-AMS netlist generated by the AMS netlister, version ICOA5.2.51.500.7.
// Cadence Design Systems, Inc.

`include "disciplines.vams"

module tiehi_hv ( Y );

output   Y;

wire (*
integer inh_conn_prop_name = "DVDD";
integer
inh_conn_def_value = "cds_globals.\\VDD! ";
 *)
\VDD! ;
wire (*
integer inh_conn_prop_name = "DVSS";
integer
inh_conn_def_value = "cds_globals.\\VSS! ";
 *)
\VSS! ;

gpdk090_pmos2v #(.ps(4u), .m(1 * 1), .as(840f), .l(280.0n), .pd(4u), .ad(840f),
 .w(1.4u)) (*
integer library_binding = "gpdk090";
integer
passed_mfactor = "m";
 *)
PM0 ( Y, net20, \VDD! , \VDD!  );

gpdk090_nmos2v #(.ps(2.8u), .m(1 * 1), .as(440f), .l(280.0n), .pd(2.8u),
 .ad(440f), .w(400n)) (*
integer library_binding = "gpdk090";
integer
passed_mfactor = "m";
 *)
NM0 ( net20, net20, \VSS! , \VSS!  );

endmodule
