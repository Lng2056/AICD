// Verilog-AMS netlist generated by the AMS netlister, version ICOA5.2.51.500.7.
// Cadence Design Systems, Inc.

`include "disciplines.vams"

module Bias_bdgp_amp ( INn,SEL,VBG,VDD,INp,PD,OUT,VSS );

input   INn;
input [15:0]  SEL;
input   VBG;
input   VDD;
input
 INp;
input   PD;
output   OUT;
input   VSS;

gpdk090_resnsppoly #(.w(2u), .r(29.4984K), .l(147.484u)) (*
integer
library_binding = "gpdk090";
 *)
R0 ( PREF, net073, VDD );
gpdk090_resnsppoly #(.w(2u), .r(30.0008K), .l(150.029u)) (*
integer
library_binding = "gpdk090";
 *)
R2 ( net12, net27, VDD );

gpdk090_pmos2v #(.ps(33.86u), .m(1 * 2), .as(9.798p), .l(280.0n), .pd(16.93u),
 .ad(4.899p), .w(16.33u)) (*
integer library_binding = "gpdk090";

integer passed_mfactor = "m";
 *)
PM5 ( OUT, PREF, net0160, VDD );
gpdk090_pmos2v #(.ps(17.2u), .m(1 * 2), .as(4.8p), .l(2u), .pd(8.6u),
.ad(2.4p), .w(8u)) (*
integer library_binding = "gpdk090";
integer
passed_mfactor = "m";
 *)
PM21 ( NREF, PREF, VDD, VDD );
gpdk090_pmos2v #(.ps(33.86u), .m(1 * 2), .as(9.798p), .l(280.0n), .pd(16.93u),
 .ad(4.899p), .w(16.33u)) (*
integer library_binding = "gpdk090";

integer passed_mfactor = "m";
 *)
PM0 ( net108, PREF, net0164, VDD );
gpdk090_pmos2v #(.ps(2.8u), .m(1 * 1), .as(476f), .l(280.0n), .pd(2.8u),
 .ad(476f), .w(580n)) (*
integer library_binding = "gpdk090";
integer
passed_mfactor = "m";
 *)
PM14 ( PDb, PD, VDD, VDD );
gpdk090_pmos2v #(.ps(2.8u), .m(1 * 1), .as(476f), .l(280.0n), .pd(2.8u),
 .ad(476f), .w(580n)) (*
integer library_binding = "gpdk090";
integer
passed_mfactor = "m";
 *)
PM13 ( OUT, PDb, VDD, VDD );
gpdk090_pmos2v #(.ps(2.8u), .m(1 * 1), .as(476f), .l(280.0n), .pd(2.8u),
 .ad(476f), .w(580n)) (*
integer library_binding = "gpdk090";
integer
passed_mfactor = "m";
 *)
PM12 ( net12, PD, VDD, VDD );
gpdk090_pmos2v #(.ps(12.9u), .m(1 * 4), .as(3.6p), .l(2u), .pd(8.6u),
.ad(2.4p), .w(8u)) (*
integer library_binding = "gpdk090";
integer
passed_mfactor = "m";
 *)
PM11 ( PREF, PREF, VDD, VDD );
gpdk090_pmos2v #(.ps(2.8u), .m(1 * 1), .as(476f), .l(280.0n), .pd(2.8u),
 .ad(476f), .w(580n)) (*
integer library_binding = "gpdk090";
integer
passed_mfactor = "m";
 *)
PM9 ( PREF, PDb, VDD, VDD );
gpdk090_pmos2v #(.ps(2.8u), .m(1 * 1), .as(476f), .l(280.0n), .pd(2.8u),
 .ad(476f), .w(580n)) (*
integer library_binding = "gpdk090";
integer
passed_mfactor = "m";
 *)
PM7 ( net108, PDb, VDD, VDD );
gpdk090_pmos2v #(.ps(29.2u), .m(1 * 2), .as(8.4p), .l(4u), .pd(14.6u),
 .ad(4.2p), .w(14u)) (*
integer library_binding = "gpdk090";
integer
passed_mfactor = "m";
 *)
PM1 ( net0164, net108, net055, VDD );
gpdk090_pmos2v #(.ps(29.2u), .m(1 * 2), .as(8.4p), .l(4u), .pd(14.6u),
 .ad(4.2p), .w(14u)) (*
integer library_binding = "gpdk090";
integer
passed_mfactor = "m";
 *)
PM6 ( net0160, net108, net0169, VDD );
gpdk090_pmos2v #(.ps(23.175u), .m(1 * 16), .as(6.75p), .l(480.0n), .pd(20.6u),
 .ad(6p), .w(20u)) (*
integer library_binding = "gpdk090";
integer
passed_mfactor = "m";
 *)
PM3 ( net59, INn, net132, VDD );
gpdk090_pmos2v #(.ps(17.2u), .m(1 * 1), .as(4.8p), .l(2u), .pd(17.2u),
 .ad(4.8p), .w(8u)) (*
integer library_binding = "gpdk090";
integer
passed_mfactor = "m";
 *)
PM2 ( net132, PREF, VDD, VDD );
gpdk090_pmos2v #(.ps(23.175u), .m(1 * 16), .as(6.75p), .l(480.0n), .pd(20.6u),
 .ad(6p), .w(20u)) (*
integer library_binding = "gpdk090";
integer
passed_mfactor = "m";
 *)
PM4 ( net73, INp, net132, VDD );

gpdk090_nmos2v #(.ps(7.02u), .m(1 * 2), .as(1.746p), .l(280.0n), .pd(3.51u),
 .ad(873f), .w(2.91u)) (*
integer library_binding = "gpdk090";

integer passed_mfactor = "m";
 *)
NM1 ( net59, NREF, net65, VSS );
gpdk090_nmos2v #(.ps(2.8u), .m(1 * 1), .as(476f), .l(280.0n), .pd(2.8u),
 .ad(476f), .w(580n)) (*
integer library_binding = "gpdk090";
integer
passed_mfactor = "m";
 *)
NM18 ( net27, PD, VSS, VSS );
gpdk090_nmos2v #(.ps(2.8u), .m(1 * 1), .as(476f), .l(280.0n), .pd(2.8u),
 .ad(476f), .w(580n)) (*
integer library_binding = "gpdk090";
integer
passed_mfactor = "m";
 *)
NM16 ( net73, PD, VSS, VSS );
gpdk090_nmos2v #(.ps(2.8u), .m(1 * 1), .as(476f), .l(280.0n), .pd(2.8u),
 .ad(476f), .w(580n)) (*
integer library_binding = "gpdk090";
integer
passed_mfactor = "m";
 *)
NM15 ( net59, PD, VSS, VSS );
gpdk090_nmos2v #(.ps(2.8u), .m(1 * 1), .as(476f), .l(280.0n), .pd(2.8u),
 .ad(476f), .w(580n)) (*
integer library_binding = "gpdk090";
integer
passed_mfactor = "m";
 *)
NM14 ( PDb, PD, VSS, VSS );
gpdk090_nmos2v #(.ps(2.8u), .m(1 * 2), .as(476f), .l(280.0n), .pd(1.6u),
 .ad(296f), .w(580n)) (*
integer library_binding = "gpdk090";
integer
passed_mfactor = "m";
 *)
NM13 ( net27, net27, net33, VSS );
gpdk090_nmos2v #(.ps(24.52u), .m(1 * 1), .as(6.996p), .l(280.0n), .pd(24.52u),
 .ad(6.996p), .w(11.66u)) (*
integer library_binding = "gpdk090";

integer passed_mfactor = "m";
 *)
NM17 ( net073, PDb, VSS, VSS );
gpdk090_nmos2v #(.ps(2.8u), .m(1 * 1), .as(476f), .l(280.0n), .pd(2.8u),
 .ad(476f), .w(580n)) (*
integer library_binding = "gpdk090";
integer
passed_mfactor = "m";
 *)
NM10 ( VDD, net27, VBG, VSS );
gpdk090_nmos2v #(.ps(2.8u), .m(1 * 1), .as(476f), .l(280.0n), .pd(2.8u),
 .ad(476f), .w(580n)) (*
integer library_binding = "gpdk090";
integer
passed_mfactor = "m";
 *)
NM11 ( VBG, PD, VSS, VSS );
gpdk090_nmos2v #(.ps(9.2u), .m(1 * 1), .as(2.4p), .l(4u), .pd(9.2u), .ad(2.4p),
 .w(4u)) (*
integer library_binding = "gpdk090";
integer
passed_mfactor = "m";
 *)
NM8 ( NREF, NREF, VSS, VSS );
gpdk090_nmos2v #(.ps(7.02u), .m(1 * 2), .as(1.746p), .l(280.0n), .pd(3.51u),
 .ad(873f), .w(2.91u)) (*
integer library_binding = "gpdk090";

integer passed_mfactor = "m";
 *)
NM7 ( OUT, NREF, net53, VSS );
gpdk090_nmos2v #(.ps(6.2u), .m(1 * 2), .as(1.5p), .l(4u), .pd(3.1u), .ad(750f),
 .w(2.5u)) (*
integer library_binding = "gpdk090";
integer
passed_mfactor = "m";
 *)
NM6 ( net53, net73, VSS, VSS );
gpdk090_nmos2v #(.ps(6.2u), .m(1 * 2), .as(1.5p), .l(4u), .pd(3.1u), .ad(750f),
 .w(2.5u)) (*
integer library_binding = "gpdk090";
integer
passed_mfactor = "m";
 *)
NM5 ( net57, net59, VSS, VSS );
gpdk090_nmos2v #(.ps(7.02u), .m(1 * 2), .as(1.746p), .l(280.0n), .pd(3.51u),
 .ad(873f), .w(2.91u)) (*
integer library_binding = "gpdk090";

integer passed_mfactor = "m";
 *)
NM4 ( net108, NREF, net57, VSS );
gpdk090_nmos2v #(.ps(7.02u), .m(1 * 2), .as(1.746p), .l(280.0n), .pd(3.51u),
 .ad(873f), .w(2.91u)) (*
integer library_binding = "gpdk090";

integer passed_mfactor = "m";
 *)
NM3 ( net73, NREF, net77, VSS );
gpdk090_nmos2v #(.ps(6.2u), .m(1 * 2), .as(1.5p), .l(4u), .pd(3.1u), .ad(750f),
 .w(2.5u)) (*
integer library_binding = "gpdk090";
integer
passed_mfactor = "m";
 *)
NM2 ( net77, net73, VSS, VSS );
gpdk090_nmos2v #(.ps(2.8u), .m(1 * 2), .as(476f), .l(280.0n), .pd(1.6u),
 .ad(296f), .w(580n)) (*
integer library_binding = "gpdk090";
integer
passed_mfactor = "m";
 *)
NM12 ( net33, net33, VSS, VSS );
gpdk090_nmos2v #(.ps(6.2u), .m(1 * 2), .as(1.5p), .l(4u), .pd(3.1u), .ad(750f),
 .w(2.5u)) (*
integer library_binding = "gpdk090";
integer
passed_mfactor = "m";
 *)
NM0 ( net65, net59, VSS, VSS );

gpdk090_pmoscap2v #(.m(1 * 1), .l(11.385u), .w(10.675u)) (*
integer
library_binding = "gpdk090";
integer passed_mfactor = "m";
 *)
C0 (
VDD, OUT, VDD, VDD );

Bias_bdgp_trim (*
integer library_binding = "ether";
 *)
I0 ( .SEL(
SEL[15:0] ), .VDD( VDD ), .B( net055 ), .A( net0169 ) );

endmodule
