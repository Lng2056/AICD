// Verilog-AMS netlist generated by the AMS netlister, version ICOA5.2.51.500.7.
// Cadence Design Systems, Inc.

`include "disciplines.vams"

module DEC_4to16 ( S,OUT );

input [3:0]  S;
output [15:0]  OUT;

nor2_1x_hv (*
integer library_binding = "ether";
 *)
U39 ( .Y( n19 ),
.B( n38 ), .A( n39 ) );

or2_2x_hv (*
integer library_binding = "ether";
 *)
U77 ( .Y( n56 ), .B(
n17 ), .A( S[3] ) );

and4_2x_hv (*
integer library_binding = "ether";
 *)
U45 ( .D( n33 ),
.C( n42 ), .Y( n29 ), .B( n41 ), .A( n22 ) );

and4_1x_hv (*
integer library_binding = "ether";
 *)
U71 ( .D( n28 ),
.C( n27 ), .Y( n40 ), .B( n31 ), .A( n41 ) );

and3_2x_hv (*
integer library_binding = "ether";
 *)
U43 ( .C( n40 ),
.Y( n21 ), .B( n36 ), .A( n24 ) );
and3_2x_hv (*
integer library_binding = "ether";
 *)
U44 ( .C( n22 ),
.Y( n23 ), .B( n33 ), .A( n40 ) );

nand3_2x_hv (*
integer library_binding = "ether";
 *)
U73 ( .C( n29 ),
.Y( OUT[3] ), .B( n28 ), .A( n31 ) );
nand3_2x_hv (*
integer library_binding = "ether";
 *)
U70 ( .C( n29 ),
.Y( OUT[5] ), .B( n28 ), .A( n27 ) );
nand3_2x_hv (*
integer library_binding = "ether";
 *)
U72 ( .C( n29 ),
.Y( OUT[1] ), .B( n46 ), .A( n31 ) );
nand3_2x_hv (*
integer library_binding = "ether";
 *)
U68 ( .C( n21 ),
.Y( OUT[12] ), .B( n35 ), .A( n33 ) );
nand3_2x_hv (*
integer library_binding = "ether";
 *)
U69 ( .C( n21 ),
.Y( OUT[14] ), .B( n34 ), .A( n33 ) );

inv_2x_hv (*
integer library_binding = "ether";
 *)
U50 ( .Y( n45 ), .A(
n44 ) );
inv_2x_hv (*
integer library_binding = "ether";
 *)
U49 ( .Y( n44 ), .A(
S[2] ) );
inv_2x_hv (*
integer library_binding = "ether";
 *)
U64 ( .Y( OUT[13] ),
.A( n52 ) );
inv_2x_hv (*
integer library_binding = "ether";
 *)
U62 ( .Y( OUT[6] ),
.A( n50 ) );
inv_2x_hv (*
integer library_binding = "ether";
 *)
U78 ( .Y( n57 ), .A(
n56 ) );
inv_2x_hv (*
integer library_binding = "ether";
 *)
U60 ( .Y( OUT[4] ),
.A( n48 ) );
inv_2x_hv (*
integer library_binding = "ether";
 *)
U52 ( .Y( n17 ), .A(
n38 ) );

clkbuf_2x_hv (*
integer library_binding = "ether";
 *)
U66 ( .Y(
OUT[10] ), .A( n59 ) );
clkbuf_2x_hv (*
integer library_binding = "ether";
 *)
U58 ( .Y(
OUT[15] ), .A( n58 ) );
clkbuf_2x_hv (*
integer library_binding = "ether";
 *)
U75 ( .Y( n55 ),
.A( n19 ) );

nand2_2x_hv (*
integer library_binding = "ether";
 *)
U57 ( .Y( OUT[8] ),
.B( n22 ), .A( n21 ) );
nand2_2x_hv (*
integer library_binding = "ether";
 *)
U76 ( .Y( OUT[9] ),
.B( n20 ), .A( n55 ) );
nand2_2x_hv (*
integer library_binding = "ether";
 *)
U80 ( .Y( n33 ),
.B( n20 ), .A( S[3] ) );
nand2_2x_hv (*
integer library_binding = "ether";
 *)
U55 ( .Y( OUT[0] ),
.B( n20 ), .A( n57 ) );
nand2_2x_hv (*
integer library_binding = "ether";
 *)
U65 ( .Y( OUT[7] ),
.B( n24 ), .A( n23 ) );
nand2_2x_hv (*
integer library_binding = "ether";
 *)
U54 ( .Y( n28 ),
.B( n20 ), .A( S[0] ) );
nand2_2x_hv (*
integer library_binding = "ether";
 *)
U56 ( .Y(
OUT[11] ), .B( n32 ), .A( n55 ) );
nand2_2x_hv (*
integer library_binding = "ether";
 *)
U79 ( .Y( OUT[2] ),
.B( n32 ), .A( n57 ) );

nor2_4x_hv (*
integer library_binding = "ether";
 *)
U81 ( .Y( n20 ),
.B( n43 ), .A( n45 ) );
nor2_4x_hv (*
integer library_binding = "ether";
 *)
U83 ( .Y( n32 ),
.B( n45 ), .A( n37 ) );

and2_1x_hv (*
integer library_binding = "ether";
 *)
U37 ( .Y( n26 ),
.B( S[1] ), .A( n45 ) );
and2_1x_hv (*
integer library_binding = "ether";
 *)
U61 ( .Y( n50 ),
.B( n26 ), .A( n57 ) );
and2_1x_hv (*
integer library_binding = "ether";
 *)
U63 ( .Y( n52 ),
.B( n30 ), .A( n55 ) );
and2_1x_hv (*
integer library_binding = "ether";
 *)
U42 ( .Y( n22 ),
.B( n35 ), .A( n34 ) );
and2_1x_hv (*
integer library_binding = "ether";
 *)
U59 ( .Y( n48 ),
.B( n30 ), .A( n57 ) );
and2_1x_hv (*
integer library_binding = "ether";
 *)
U38 ( .Y( n30 ),
.B( n37 ), .A( n45 ) );
and2_1x_hv (*
integer library_binding = "ether";
 *)
U46 ( .Y( n42 ),
.B( n24 ), .A( n36 ) );

nand2_1x_hv (*
integer library_binding = "ether";
 *)
U67 ( .Y( n59 ),
.B( n36 ), .A( n23 ) );
nand2_1x_hv (*
integer library_binding = "ether";
 *)
U18 ( .Y( n34 ),
.B( n30 ), .A( n18 ) );
nand2_1x_hv (*
integer library_binding = "ether";
 *)
U17 ( .Y( n35 ),
.B( n26 ), .A( n18 ) );
nand2_1x_hv (*
integer library_binding = "ether";
 *)
U10 ( .Y( n36 ),
.B( n26 ), .A( S[0] ) );
nand2_1x_hv (*
integer library_binding = "ether";
 *)
U30 ( .Y( n58 ),
.B( n26 ), .A( n55 ) );
nand2_1x_hv (*
integer library_binding = "ether";
 *)
U47 ( .Y( n41 ),
.B( n39 ), .A( n38 ) );
nand2_1x_hv (*
integer library_binding = "ether";
 *)
U53 ( .Y( n27 ),
.B( n32 ), .A( n17 ) );
nand2_1x_hv (*
integer library_binding = "ether";
 *)
U82 ( .Y( n24 ),
.B( n32 ), .A( n18 ) );
nand2_1x_hv (*
integer library_binding = "ether";
 *)
U74 ( .Y( n31 ),
.B( n30 ), .A( n17 ) );
nand2_1x_hv (*
integer library_binding = "ether";
 *)
U51 ( .Y( n46 ),
.B( n32 ), .A( n17 ) );

inv_1x_hv (*
integer library_binding = "ether";
 *)
U15 ( .Y( n18 ), .A(
n39 ) );
inv_1x_hv (*
integer library_binding = "ether";
 *)
U40 ( .Y( n37 ), .A(
S[1] ) );
inv_1x_hv (*
integer library_binding = "ether";
 *)
U20 ( .Y( n39 ), .A(
S[3] ) );
inv_1x_hv (*
integer library_binding = "ether";
 *)
U14 ( .Y( n38 ), .A(
S[0] ) );
inv_1x_hv (*
integer library_binding = "ether";
 *)
U48 ( .Y( n43 ), .A(
n37 ) );

endmodule
