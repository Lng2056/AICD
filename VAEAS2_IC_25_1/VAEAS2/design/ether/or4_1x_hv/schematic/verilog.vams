// Verilog-AMS netlist generated by the AMS netlister, version ICOA5.2.51.500.7.
// Cadence Design Systems, Inc.

`include "disciplines.vams"

module or4_1x_hv ( D,C,Y,B,A );

input   D;
input   C;
output   Y;
input   B;
input   A;

wire (*
integer inh_conn_prop_name = "DVDD";
integer
inh_conn_def_value = "cds_globals.\\VDD! ";
 *)
\VDD! ;
wire (*
integer inh_conn_prop_name = "DVSS";
integer
inh_conn_def_value = "cds_globals.\\VSS! ";
 *)
\VSS! ;

gpdk090_nmos2v #(.ps(2.8u), .m(1 * 1), .as(440f), .l(280.0n), .pd(2.8u),
 .ad(440f), .w(400n)) (*
integer library_binding = "gpdk090";
integer
passed_mfactor = "m";
 *)
NM0 ( net051, B, \VSS! , \VSS!  );
gpdk090_nmos2v #(.ps(2.8u), .m(1 * 1), .as(440f), .l(280.0n), .pd(2.8u),
 .ad(440f), .w(400n)) (*
integer library_binding = "gpdk090";
integer
passed_mfactor = "m";
 *)
NM4 ( net051, D, \VSS! , \VSS!  );
gpdk090_nmos2v #(.ps(2.8u), .m(1 * 1), .as(472f), .l(280.0n), .pd(2.8u),
 .ad(472f), .w(560n)) (*
integer library_binding = "gpdk090";
integer
passed_mfactor = "m";
 *)
NM3 ( Y, net051, \VSS! , \VSS!  );
gpdk090_nmos2v #(.ps(2.8u), .m(1 * 1), .as(440f), .l(280.0n), .pd(2.8u),
 .ad(440f), .w(400n)) (*
integer library_binding = "gpdk090";
integer
passed_mfactor = "m";
 *)
NM2 ( net051, C, \VSS! , \VSS!  );
gpdk090_nmos2v #(.ps(2.8u), .m(1 * 1), .as(440f), .l(280.0n), .pd(2.8u),
 .ad(440f), .w(400n)) (*
integer library_binding = "gpdk090";
integer
passed_mfactor = "m";
 *)
NM1 ( net051, A, \VSS! , \VSS!  );

gpdk090_pmos2v #(.ps(7.8u), .m(1 * 1), .as(1.98p), .l(280.0n), .pd(7.8u),
 .ad(1.98p), .w(3.3u)) (*
integer library_binding = "gpdk090";

integer passed_mfactor = "m";
 *)
PM4 ( net081, D, \VDD! , \VDD!  );
gpdk090_pmos2v #(.ps(4u), .m(1 * 1), .as(840f), .l(280.0n), .pd(4u), .ad(840f),
 .w(1.4u)) (*
integer library_binding = "gpdk090";
integer
passed_mfactor = "m";
 *)
PM3 ( Y, net051, \VDD! , \VDD!  );
gpdk090_pmos2v #(.ps(7.8u), .m(1 * 1), .as(1.98p), .l(280.0n), .pd(7.8u),
 .ad(1.98p), .w(3.3u)) (*
integer library_binding = "gpdk090";

integer passed_mfactor = "m";
 *)
PM2 ( net036, C, net081, \VDD!  );
gpdk090_pmos2v #(.ps(7.8u), .m(1 * 1), .as(1.98p), .l(280.0n), .pd(7.8u),
 .ad(1.98p), .w(3.3u)) (*
integer library_binding = "gpdk090";

integer passed_mfactor = "m";
 *)
PM1 ( net051, A, net027, \VDD!  );
gpdk090_pmos2v #(.ps(7.8u), .m(1 * 1), .as(1.98p), .l(280.0n), .pd(7.8u),
 .ad(1.98p), .w(3.3u)) (*
integer library_binding = "gpdk090";

integer passed_mfactor = "m";
 *)
PM0 ( net027, B, net036, \VDD!  );

endmodule
