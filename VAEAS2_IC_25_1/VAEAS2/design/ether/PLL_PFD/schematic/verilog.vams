// Verilog-AMS netlist generated by the AMS netlister, version ICOA5.2.51.500.7.
// Cadence Design Systems, Inc.

`include "disciplines.vams"

module PLL_PFD ( VDD,REFCLK,UP,PD,VSS,FBCLK,DN );

input   VDD;
input   REFCLK;
output   UP;
input   PD;
input   VSS;

input   FBCLK;
output   DN;

parameter ttol=0;

capacitor #(.c(6.6f)) (*
integer library_binding = "analogLib";
 *)
C5
 ( net93, VSS );
capacitor #(.c(6f)) (*
integer library_binding = "analogLib";
 *)
C3
 ( Rb, VSS );
capacitor #(.c(1.4f)) (*
integer library_binding = "analogLib";
 *)
C0
 ( net048, VSS );
capacitor #(.c(2.7f)) (*
integer library_binding = "analogLib";
 *)
C2
 ( net63, VSS );
capacitor #(.c(2.7f)) (*
integer library_binding = "analogLib";
 *)
C1
 ( net65, VSS );
capacitor #(.c(7f)) (*
integer library_binding = "analogLib";
 *)
C4
 ( net91, VSS );
capacitor #(.c(3.1f)) (*
integer library_binding = "analogLib";
 *)
C6
 ( qbUP, VSS );
capacitor #(.c(3.2f)) (*
integer library_binding = "analogLib";
 *)
C7
 ( qbDN, VSS );

dly1_1x_hv (*
integer library_binding = "ether";
integer cds_net_set
[0:1] = { "DVSS","DVDD" };
integer DVSS = "VSS";
integer DVDD
 = "VDD";
 *)
I22 ( .Y( net63 ), .A( net65 ) );
dly1_1x_hv (*
integer library_binding = "ether";
integer cds_net_set
[0:1] = { "DVDD","DVSS" };
integer DVDD = "VDD";
integer DVSS
 = "VSS";
 *)
I23 ( .Y( Rb ), .A( net63 ) );
dly1_1x_hv (*
integer library_binding = "ether";
integer cds_net_set
[0:1] = { "DVDD","DVSS" };
integer DVDD = "VDD";
integer DVSS
 = "VSS";
 *)
I62 ( .Y( net042 ), .A( net071 ) );
dly1_1x_hv (*
integer library_binding = "ether";
integer cds_net_set
[0:1] = { "DVDD","DVSS" };
integer DVDD = "VDD";
integer DVSS
 = "VSS";
 *)
I64 ( .Y( net044 ), .A( VSS ) );
dly1_1x_hv (*
integer library_binding = "ether";
integer cds_net_set
[0:1] = { "DVDD","DVSS" };
integer DVDD = "VDD";
integer DVSS
 = "VSS";
 *)
I65 ( .Y( net043 ), .A( net044 ) );
dly1_1x_hv (*
integer library_binding = "ether";
integer cds_net_set
[0:1] = { "DVDD","DVSS" };
integer DVDD = "VDD";
integer DVSS
 = "VSS";
 *)
I61 ( .Y( net048 ), .A( net042 ) );
dly1_1x_hv (*
integer library_binding = "ether";
integer cds_net_set
[0:1] = { "DVDD","DVSS" };
integer DVDD = "VDD";
integer DVSS
 = "VSS";
 *)
I21 ( .Y( net65 ), .A( net048 ) );

or2_2x_hv (*
integer library_binding = "ether";
integer cds_net_set
[0:1] = { "DVSS","DVDD" };
integer DVSS = "VSS";
integer DVDD
 = "VDD";
 *)
I24 ( .Y( net071 ), .B( net93 ), .A( net91 ) );

clkbuf_16x_hv (*
integer library_binding = "ether";
integer
cds_net_set[0:1] = { "DVDD","DVSS" };
integer DVDD = "VDD";
integer
DVSS = "VSS";
 *)
I32 ( .Y( UP ), .A( net95 ) );
clkbuf_16x_hv (*
integer library_binding = "ether";
integer
cds_net_set[0:1] = { "DVSS","DVDD" };
integer DVSS = "VSS";
integer
DVDD = "VDD";
 *)
I36 ( .Y( DN ), .A( net89 ) );

clkbuf_3x_hv (*
integer library_binding = "ether";
integer cds_net_set
[0:1] = { "DVDD","DVSS" };
integer DVDD = "VDD";
integer DVSS
 = "VSS";
 *)
I31 ( .Y( net95 ), .A( qUP ) );
clkbuf_3x_hv (*
integer library_binding = "ether";
integer cds_net_set
[0:1] = { "DVSS","DVDD" };
integer DVSS = "VSS";
integer DVDD
 = "VDD";
 *)
I35 ( .Y( net89 ), .A( qDN ) );
clkbuf_3x_hv (*
integer library_binding = "ether";
integer cds_net_set
[0:1] = { "DVSS","DVDD" };
integer DVSS = "VSS";
integer DVDD
 = "VDD";
 *)
I34 ( .Y( net93 ), .A( qbDN ) );
clkbuf_3x_hv (*
integer library_binding = "ether";
integer cds_net_set
[0:1] = { "DVSS","DVDD" };
integer DVSS = "VSS";
integer DVDD
 = "VDD";
 *)
I33 ( .Y( net91 ), .A( qbUP ) );

dffnr_2x_hv (*
integer library_binding = "ether";
integer cds_net_set
[0:1] = { "DVSS","DVDD" };
integer DVSS = "VSS";
integer DVDD
 = "VDD";
 *)
I15 ( .CKN( net42 ), .QN( qbDN ), .D( net61 ), .RN( Rb ),
.Q( qDN ) );
dffnr_2x_hv (*
integer library_binding = "ether";
integer cds_net_set
[0:1] = { "DVDD","DVSS" };
integer DVDD = "VDD";
integer DVSS
 = "VSS";
 *)
I14 ( .CKN( net45 ), .QN( qbUP ), .D( net100 ), .RN( Rb ),
.Q( qUP ) );

tiehi_hv (*
integer library_binding = "ether";
integer cds_net_set
[0:1] = { "DVSS","DVDD" };
integer DVSS = "VSS";
integer DVDD
 = "VDD";
 *)
I47 ( .Y( net61 ) );
tiehi_hv (*
integer library_binding = "ether";
integer cds_net_set
[0:1] = { "DVDD","DVSS" };
integer DVDD = "VDD";
integer DVSS
 = "VSS";
 *)
I45 ( .Y( net100 ) );

nor2_2x_hv (*
integer library_binding = "ether";
integer cds_net_set
[0:1] = { "DVSS","DVDD" };
integer DVSS = "VSS";
integer DVDD
 = "VDD";
 *)
I13 ( .Y( net42 ), .B( PD ), .A( FBCLK ) );
nor2_2x_hv (*
integer library_binding = "ether";
integer cds_net_set
[0:1] = { "DVDD","DVSS" };
integer DVDD = "VDD";
integer DVSS
 = "VSS";
 *)
I12 ( .Y( net45 ), .B( PD ), .A( REFCLK ) );

endmodule
