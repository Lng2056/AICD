// Verilog-AMS netlist generated by the AMS netlister, version ICOA5.2.51.500.7.
// Cadence Design Systems, Inc.

`include "disciplines.vams"

module tenbt_rec_slicer ( INP,vss,vdd,Vbias_Poly,INN,siddq,vbias_const,
OUT );

input   INP;
input   vss;
input   vdd;
input   Vbias_Poly;
input
 INN;
input   siddq;
input   vbias_const;
output   OUT;

gpdk090_resnsppoly #(.w(2u), .r(17.9998K), .l(89.9943u)) (*
integer
library_binding = "gpdk090";
 *)
R0 ( vdd, net43, vss );
gpdk090_resnsppoly #(.w(2u), .r(17.9998K), .l(89.9943u)) (*
integer
library_binding = "gpdk090";
 *)
R1 ( vdd, net59, vss );

gpdk090_pmos2v #(.ps(2.8u), .m(1 * 1), .as(462f), .l(280.0n), .pd(2.8u),
 .ad(462f), .w(510n)) (*
integer library_binding = "gpdk090";
integer
passed_mfactor = "m";
 *)
PM12 ( net74, net206, vdd, vdd );
gpdk090_pmos2v #(.ps(2.8u), .m(1 * 1), .as(462f), .l(280.0n), .pd(2.8u),
 .ad(462f), .w(510n)) (*
integer library_binding = "gpdk090";
integer
passed_mfactor = "m";
 *)
PM4 ( net80, net206, vdd, vdd );
gpdk090_pmos2v #(.ps(2.8u), .m(1 * 1), .as(462f), .l(280.0n), .pd(2.8u),
 .ad(462f), .w(510n)) (*
integer library_binding = "gpdk090";
integer
passed_mfactor = "m";
 *)
PM5 ( net47, net206, vdd, vdd );
gpdk090_pmos2v #(.ps(11.2u), .m(1 * 2), .as(3p), .l(280.0n), .pd(5.6u),
 .ad(1.5p), .w(5u)) (*
integer library_binding = "gpdk090";
integer
passed_mfactor = "m";
 *)
PM3 ( single_node, net47, vdd, vdd );
gpdk090_pmos2v #(.ps(11.2u), .m(1 * 2), .as(3p), .l(280.0n), .pd(5.6u),
 .ad(1.5p), .w(5u)) (*
integer library_binding = "gpdk090";
integer
passed_mfactor = "m";
 *)
M22 ( net80, net80, vdd, vdd );
gpdk090_pmos2v #(.ps(11.2u), .m(1 * 2), .as(3p), .l(280.0n), .pd(5.6u),
 .ad(1.5p), .w(5u)) (*
integer library_binding = "gpdk090";
integer
passed_mfactor = "m";
 *)
M21 ( net47, net47, vdd, vdd );
gpdk090_pmos2v #(.ps(11.2u), .m(1 * 2), .as(3p), .l(280.0n), .pd(5.6u),
 .ad(1.5p), .w(5u)) (*
integer library_binding = "gpdk090";
integer
passed_mfactor = "m";
 *)
PM2 ( net42, net80, vdd, vdd );
gpdk090_pmos2v #(.ps(2.8u), .m(1 * 1), .as(462f), .l(280.0n), .pd(2.8u),
 .ad(462f), .w(510n)) (*
integer library_binding = "gpdk090";
integer
passed_mfactor = "m";
 *)
PM13 ( net34, net206, vdd, vdd );
gpdk090_pmos2v #(.ps(2.8u), .m(1 * 1), .as(462f), .l(280.0n), .pd(2.8u),
 .ad(462f), .w(510n)) (*
integer library_binding = "gpdk090";
integer
passed_mfactor = "m";
 *)
PM6 ( single_node, net206, vdd, vdd );

gpdk090_nmos2v #(.ps(2.8u), .m(1 * 1), .as(462f), .l(280.0n), .pd(2.8u),
 .ad(462f), .w(510n)) (*
integer library_binding = "gpdk090";
integer
passed_mfactor = "m";
 *)
NM5 ( net42, siddq, vss, vss );
gpdk090_nmos2v #(.ps(37.2u), .m(1 * 2), .as(10.8p), .l(2u), .pd(18.6u),
 .ad(5.4p), .w(18u)) (*
integer library_binding = "gpdk090";
integer
passed_mfactor = "m";
 *)
M33 ( net74, Vbias_Poly, vss, vss );
gpdk090_nmos2v #(.ps(21.2u), .m(2 * 2), .as(6p), .l(280.0n), .pd(10.6u),
 .ad(3p), .w(10u)) (*
integer library_binding = "gpdk090";
integer
passed_mfactor = "m";
 *)
M31 ( net43, INP, net74, vss );
gpdk090_nmos2v #(.ps(1.6u), .m(2 * 2), .as(300f), .l(280n), .pd(360n),
 .ad(180f), .w(1u)) (*
integer library_binding = "gpdk090";
integer
passed_mfactor = "m";
 *)
M14 ( net47, net59, net34, vss );
gpdk090_nmos2v #(.ps(21.2u), .m(1 * 2), .as(6p), .l(2u), .pd(10.6u), .ad(3p),
 .w(10u)) (*
integer library_binding = "gpdk090";
integer
passed_mfactor = "m";
 *)
M18 ( net34, vbias_const, vss, vss );
gpdk090_nmos2v #(.ps(21.2u), .m(2 * 2), .as(6p), .l(280.0n), .pd(10.6u),
 .ad(3p), .w(10u)) (*
integer library_binding = "gpdk090";
integer
passed_mfactor = "m";
 *)
M32 ( net59, INN, net74, vss );
gpdk090_nmos2v #(.ps(1.01u), .m(1 * 1), .as(72.6f), .l(280.0n), .pd(1.01u),
 .ad(72.6f), .w(150n)) (*
integer library_binding = "gpdk090";

integer passed_mfactor = "m";
 *)
NM0 ( net42, net42, vss, vss );
gpdk090_nmos2v #(.ps(1.6u), .m(2 * 2), .as(300f), .l(280n), .pd(360n),
 .ad(180f), .w(1u)) (*
integer library_binding = "gpdk090";
integer
passed_mfactor = "m";
 *)
M16 ( net80, net43, net34, vss );
gpdk090_nmos2v #(.ps(1.01u), .m(1 * 1), .as(72.6f), .l(280.0n), .pd(1.01u),
 .ad(72.6f), .w(150n)) (*
integer library_binding = "gpdk090";

integer passed_mfactor = "m";
 *)
NM1 ( single_node, net42, vss, vss );

inv_8x_hv (*
integer library_binding = "ether";
integer cds_net_set
[0:1] = { "DVSS","DVDD" };
integer DVSS = "vss";
integer DVDD
 = "vdd";
 *)
I14 ( .Y( OUT ), .A( net061 ) );

inv_4x_hv (*
integer library_binding = "ether";
integer cds_net_set
[0:1] = { "DVDD","DVSS" };
integer DVDD = "vdd";
integer DVSS
 = "vss";
 *)
I13 ( .Y( net061 ), .A( net063 ) );

inv_3x_hv (*
integer library_binding = "ether";
integer cds_net_set
[0:1] = { "DVSS","DVDD" };
integer DVSS = "vss";
integer DVDD
 = "vdd";
 *)
I12 ( .Y( net063 ), .A( net067 ) );

inv_2x_hv (*
integer library_binding = "ether";
integer cds_net_set
[0:1] = { "DVDD","DVSS" };
integer DVDD = "vdd";
integer DVSS
 = "vss";
 *)
I7 ( .Y( net067 ), .A( net196 ) );

inv_1x_hv (*
integer library_binding = "ether";
integer cds_net_set
[0:1] = { "DVSS","DVDD" };
integer DVSS = "vss";
integer DVDD
 = "vdd";
 *)
I11 ( .Y( net196 ), .A( single_node ) );

inv_1X (*
integer library_binding = "ether";
 *)
I6 ( .vss( vss ), .VDD(
vdd ), .in( siddq ), .out( net206 ) );

endmodule
