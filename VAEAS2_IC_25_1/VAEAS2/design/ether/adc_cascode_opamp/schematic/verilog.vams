// Verilog-AMS netlist generated by the AMS netlister, version ICOA5.2.51.500.7.
// Cadence Design Systems, Inc.

`include "disciplines.vams"

module adc_cascode_opamp ( OUT,VSS,VDD,INN,INP,IREF,SIDDQ );

output   OUT;
input   VSS;
input   VDD;
input   INN;
input   INP;

input   IREF;
input   SIDDQ;

gpdk090_nmos2v #(.ps(2.8u), .m(1 * 1), .as(464f), .l(280.0n), .pd(2.8u),
 .ad(464f), .w(520n)) (*
integer library_binding = "gpdk090";
integer
passed_mfactor = "m";
 *)
NM8 ( net52, SIDDQ, VSS, VSS );
gpdk090_nmos2v #(.ps(3.6u), .m(1 * 2), .as(720f), .l(280.0n), .pd(1.8u),
 .ad(360f), .w(1.2u)) (*
integer library_binding = "gpdk090";
integer
passed_mfactor = "m";
 *)
NM1 ( SIDDQb, SIDDQ, VSS, VSS );
gpdk090_nmos2v #(.ps(1.01u), .m(1 * 1), .as(72.6f), .l(500n), .pd(1.01u),
 .ad(72.6f), .w(150n)) (*
integer library_binding = "gpdk090";

integer passed_mfactor = "m";
 *)
NM15 ( net0189, net0189, net0193,
VSS );
gpdk090_nmos2v #(.ps(13.2u), .m(1 * 1), .as(3.6p), .l(2u), .pd(13.2u),
 .ad(3.6p), .w(6u)) (*
integer library_binding = "gpdk090";
integer
passed_mfactor = "m";
 *)
M9 ( net16, net32, VSS, VSS );
gpdk090_nmos2v #(.ps(21.2u), .m(2 * 1), .as(6p), .l(2u), .pd(21.2u), .ad(6p),
 .w(10u)) (*
integer library_binding = "gpdk090";
integer
passed_mfactor = "m";
 *)
M10 ( net20, IREF, VSS, VSS );
gpdk090_nmos2v #(.ps(21.2u), .m(2 * 1), .as(6p), .l(2u), .pd(21.2u), .ad(6p),
 .w(10u)) (*
integer library_binding = "gpdk090";
integer
passed_mfactor = "m";
 *)
M11 ( net51, IREF, VSS, VSS );
gpdk090_nmos2v #(.ps(21.2u), .m(4 * 1), .as(6p), .l(2u), .pd(21.2u), .ad(6p),
 .w(10u)) (*
integer library_binding = "gpdk090";
integer
passed_mfactor = "m";
 *)
M1 ( IREF, IREF, VSS, VSS );
gpdk090_nmos2v #(.ps(11.2u), .m(1 * 2), .as(3p), .l(500n), .pd(5.6u),
.ad(1.5p), .w(5u)) (*
integer library_binding = "gpdk090";
integer
passed_mfactor = "m";
 *)
NM4 ( net32, net0189, net52, VSS );
gpdk090_nmos2v #(.ps(21.2u), .m(1 * 1), .as(6p), .l(2u), .pd(21.2u), .ad(6p),
 .w(10u)) (*
integer library_binding = "gpdk090";
integer
passed_mfactor = "m";
 *)
M14 ( net122, IREF, VSS, VSS );
gpdk090_nmos2v #(.ps(11.2u), .m(4 * 1), .as(3p), .l(1u), .pd(11.2u), .ad(3p),
 .w(5u)) (*
integer library_binding = "gpdk090";
integer
passed_mfactor = "m";
 *)
M2 ( net40, INN, net51, VSS );
gpdk090_nmos2v #(.ps(11.2u), .m(1 * 2), .as(3p), .l(500n), .pd(5.6u),
.ad(1.5p), .w(5u)) (*
integer library_binding = "gpdk090";
integer
passed_mfactor = "m";
 *)
NM5 ( OUT, net0189, net16, VSS );
gpdk090_nmos2v #(.ps(11.2u), .m(4 * 1), .as(3p), .l(1u), .pd(11.2u), .ad(3p),
 .w(5u)) (*
integer library_binding = "gpdk090";
integer
passed_mfactor = "m";
 *)
M3 ( net48, INP, net51, VSS );
gpdk090_nmos2v #(.ps(13.2u), .m(1 * 1), .as(3.6p), .l(2u), .pd(13.2u),
 .ad(3.6p), .w(6u)) (*
integer library_binding = "gpdk090";
integer
passed_mfactor = "m";
 *)
M8 ( net52, net32, VSS, VSS );
gpdk090_nmos2v #(.ps(1.01u), .m(1 * 1), .as(72.6f), .l(500n), .pd(1.01u),
 .ad(72.6f), .w(150n)) (*
integer library_binding = "gpdk090";

integer passed_mfactor = "m";
 *)
NM18 ( net0193, net0189, net0244,
VSS );
gpdk090_nmos2v #(.ps(2.8u), .m(1 * 1), .as(464f), .l(280.0n), .pd(2.8u),
 .ad(464f), .w(520n)) (*
integer library_binding = "gpdk090";
integer
passed_mfactor = "m";
 *)
NM0 ( IREF, SIDDQ, VSS, VSS );
gpdk090_nmos2v #(.ps(1.01u), .m(1 * 1), .as(72.6f), .l(500n), .pd(1.01u),
 .ad(72.6f), .w(150n)) (*
integer library_binding = "gpdk090";

integer passed_mfactor = "m";
 *)
NM17 ( net0244, net0189, net0268,
VSS );
gpdk090_nmos2v #(.ps(1.01u), .m(1 * 1), .as(72.6f), .l(500n), .pd(1.01u),
 .ad(72.6f), .w(150n)) (*
integer library_binding = "gpdk090";

integer passed_mfactor = "m";
 *)
NM11 ( net0265, net0189, net0245,
VSS );
gpdk090_nmos2v #(.ps(2.8u), .m(1 * 1), .as(464f), .l(280.0n), .pd(2.8u),
 .ad(464f), .w(520n)) (*
integer library_binding = "gpdk090";
integer
passed_mfactor = "m";
 *)
NM7 ( net32, SIDDQ, VSS, VSS );
gpdk090_nmos2v #(.ps(1.01u), .m(1 * 1), .as(72.6f), .l(500n), .pd(1.01u),
 .ad(72.6f), .w(150n)) (*
integer library_binding = "gpdk090";

integer passed_mfactor = "m";
 *)
NM14 ( net0261, net0189, VSS, VSS );
gpdk090_nmos2v #(.ps(2.8u), .m(1 * 1), .as(464f), .l(280.0n), .pd(2.8u),
 .ad(464f), .w(520n)) (*
integer library_binding = "gpdk090";
integer
passed_mfactor = "m";
 *)
NM9 ( net16, SIDDQ, VSS, VSS );
gpdk090_nmos2v #(.ps(1.01u), .m(1 * 1), .as(72.6f), .l(500n), .pd(1.01u),
 .ad(72.6f), .w(150n)) (*
integer library_binding = "gpdk090";

integer passed_mfactor = "m";
 *)
NM12 ( net0245, net0189, net0261,
VSS );
gpdk090_nmos2v #(.ps(1.01u), .m(1 * 1), .as(72.6f), .l(500n), .pd(1.01u),
 .ad(72.6f), .w(150n)) (*
integer library_binding = "gpdk090";

integer passed_mfactor = "m";
 *)
NM10 ( net0268, net0189, net0265,
VSS );

gpdk090_pmos2v #(.ps(6.4u), .m(1 * 2), .as(1.56p), .l(280.0n), .pd(3.2u),
 .ad(780f), .w(2.6u)) (*
integer library_binding = "gpdk090";
integer
passed_mfactor = "m";
 *)
PM1 ( SIDDQb, SIDDQ, VDD, VDD );
gpdk090_pmos2v #(.ps(11.2u), .m(1 * 1), .as(3p), .l(500n), .pd(11.2u),
 .ad(3p), .w(5u)) (*
integer library_binding = "gpdk090";
integer
passed_mfactor = "m";
 *)
PM5 ( net0123, net122, net139, VDD );
gpdk090_pmos2v #(.ps(11.2u), .m(1 * 1), .as(3p), .l(500n), .pd(11.2u),
 .ad(3p), .w(5u)) (*
integer library_binding = "gpdk090";
integer
passed_mfactor = "m";
 *)
PM9 ( net0106, net122, net0103, VDD );
gpdk090_pmos2v #(.ps(11.2u), .m(1 * 1), .as(3p), .l(500n), .pd(11.2u),
 .ad(3p), .w(5u)) (*
integer library_binding = "gpdk090";
integer
passed_mfactor = "m";
 *)
PM11 ( net122, net122, net0106, VDD );
gpdk090_pmos2v #(.ps(16.2u), .m(5 * 2), .as(4.5p), .l(2u), .pd(8.1u),
.ad(2.25p), .w(7.5u)) (*
integer library_binding = "gpdk090";
integer
passed_mfactor = "m";
 *)
M12 ( net20, net20, VDD, VDD );
gpdk090_pmos2v #(.ps(9.72u), .m(1 * 5), .as(2.7p), .l(2u), .pd(9.72u),
 .ad(2.7p), .w(7.5u)) (*
integer library_binding = "gpdk090";
integer
passed_mfactor = "m";
 *)
PM0 ( net0189, net20, VDD, VDD );
gpdk090_pmos2v #(.ps(21.2u), .m(1 * 2), .as(6p), .l(2u), .pd(10.6u), .ad(3p),
 .w(10u)) (*
integer library_binding = "gpdk090";
integer
passed_mfactor = "m";
 *)
M7 ( OUT, net122, net40, net40 );
gpdk090_pmos2v #(.ps(21.2u), .m(1 * 2), .as(6p), .l(2u), .pd(10.6u), .ad(3p),
 .w(10u)) (*
integer library_binding = "gpdk090";
integer
passed_mfactor = "m";
 *)
M6 ( net32, net122, net48, net48 );
gpdk090_pmos2v #(.ps(16.2u), .m(5 * 2), .as(4.5p), .l(2u), .pd(8.1u),
.ad(2.25p), .w(7.5u)) (*
integer library_binding = "gpdk090";
integer
passed_mfactor = "m";
 *)
M5 ( net40, net20, VDD, VDD );
gpdk090_pmos2v #(.ps(11.2u), .m(1 * 1), .as(3p), .l(500n), .pd(11.2u),
 .ad(3p), .w(5u)) (*
integer library_binding = "gpdk090";
integer
passed_mfactor = "m";
 *)
PM10 ( net0103, net122, net123, VDD );
gpdk090_pmos2v #(.ps(11.2u), .m(1 * 1), .as(3p), .l(500n), .pd(11.2u),
 .ad(3p), .w(5u)) (*
integer library_binding = "gpdk090";
integer
passed_mfactor = "m";
 *)
PM6 ( net0159, net122, net0123, VDD );
gpdk090_pmos2v #(.ps(16.2u), .m(5 * 2), .as(4.5p), .l(2u), .pd(8.1u),
.ad(2.25p), .w(7.5u)) (*
integer library_binding = "gpdk090";
integer
passed_mfactor = "m";
 *)
M4 ( net48, net20, VDD, VDD );
gpdk090_pmos2v #(.ps(2.8u), .m(1 * 1), .as(464f), .l(280.0n), .pd(2.8u),
 .ad(464f), .w(520n)) (*
integer library_binding = "gpdk090";
integer
passed_mfactor = "m";
 *)
PM2 ( net20, SIDDQb, VDD, VDD );
gpdk090_pmos2v #(.ps(11.2u), .m(1 * 1), .as(3p), .l(500n), .pd(11.2u),
 .ad(3p), .w(5u)) (*
integer library_binding = "gpdk090";
integer
passed_mfactor = "m";
 *)
PM7 ( net139, net122, VDD, VDD );
gpdk090_pmos2v #(.ps(11.2u), .m(1 * 1), .as(3p), .l(500n), .pd(11.2u),
 .ad(3p), .w(5u)) (*
integer library_binding = "gpdk090";
integer
passed_mfactor = "m";
 *)
PM8 ( net123, net122, net0159, VDD );

endmodule
