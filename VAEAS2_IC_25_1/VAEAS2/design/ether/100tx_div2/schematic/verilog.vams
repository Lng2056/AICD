// Verilog-AMS netlist generated by the AMS netlister, version ICOA5.2.51.500.7.
// Cadence Design Systems, Inc.

`include "disciplines.vams"

module \100tx_div2  ( IN,XTAL25,RESETN,TAP );

input [10:0]  IN;
input   XTAL25;
input   RESETN;
output [10:0]
 TAP;

clkbuf_1x_hv #(.ieIO("output"), .d2a_tr("100p"), .a2d_v0("0.5"), .d2a_tf("100p"),
 .a2d_v1("0.8"), .d2a_vh("2.5"), .a2d_tx("100p")) (*
integer
library_binding = "ether";
 *)
I18 ( .Y( RESETN_INT ), .A( RESETN ) );

and2_1x_hv #(.ieIO("output"), .d2a_tr("100p"), .a2d_v0("0.5"), .d2a_tf("100p"),
 .a2d_v1("0.8"), .d2a_vh("2.5"), .a2d_tx("100p")) (*
integer
library_binding = "ether";
 *)
I40 ( .Y( RSTb ), .B( RESETN_INT ), .A(
net014 ) );

dff_1x_hv #(.ieIO("output"), .d2a_tr("100p"), .a2d_v0("0.5"), .d2a_tf("100p"),
 .d2a_vh("2.5"), .a2d_tx("100p"), .a2d_v1("0.8")) (*
integer
library_binding = "ether";
 *)
I32 ( .QN( net011 ), .D( net03 ), .CK(
XTAL25 ), .Q( net018 ) );
dff_1x_hv #(.ieIO("output"), .d2a_tr("100p"), .a2d_v0("0.5"), .d2a_tf("100p"),
 .a2d_v1("0.8"), .d2a_vh("2.5"), .a2d_tx("100p")) (*
integer
library_binding = "ether";
 *)
I31 ( .QN( net021 ), .D( RESETN_INT ),
.CK( XTAL25 ), .Q( net03 ) );
dff_1x_hv #(.d2a_tr("100p"), .ieIO("output"), .a2d_v0("0.5"), .d2a_tf("100p"),
 .d2a_vh("2.5"), .a2d_tx("100p"), .a2d_v1("0.8")) (*
integer
library_binding = "ether";
 *)
I37 ( .QN( net06 ), .D( net018 ), .CK(
XTAL25 ), .Q( net014 ) );

dffr_2x_hv #(.d2a_tr("100p"), .ieIO("output"), .a2d_v0("0.5"), .d2a_tf("100p"),
 .a2d_v1("0.8"), .a2d_tx("100p"), .d2a_vh("2.5")) (*
integer
library_binding = "ether";
 *)
I24 ( .QN( TAP2b ), .D( TAP[8] ), .RN(
RSTb ), .CK( IN[4] ), .Q( TAP[2] ) );
dffr_2x_hv #(.d2a_tr("100p"), .ieIO("output"), .a2d_v0("0.5"), .d2a_tf("100p"),
 .a2d_v1("0.8"), .a2d_tx("100p"), .d2a_vh("2.5")) (*
integer
library_binding = "ether";
 *)
I23 ( .QN( TAP[7] ), .D( TAP2b ), .RN(
RSTb ), .CK( IN[3] ), .Q( net38 ) );
dffr_2x_hv #(.d2a_tr("100p"), .ieIO("output"), .a2d_v0("0.5"), .d2a_tf("100p"),
 .a2d_v1("0.8"), .a2d_tx("100p"), .d2a_vh("2.5")) (*
integer
library_binding = "ether";
 *)
I27 ( .QN( TAP[9] ), .D( TAP4b ), .RN(
RSTb ), .CK( IN[7] ), .Q( net024 ) );
dffr_2x_hv #(.d2a_tr("100p"), .ieIO("output"), .a2d_v0("0.5"), .d2a_tf("100p"),
 .a2d_v1("0.8"), .a2d_tx("100p"), .d2a_vh("2.5")) (*
integer
library_binding = "ether";
 *)
I22 ( .QN( TAP1b ), .D( TAP[7] ), .RN(
RSTb ), .CK( IN[2] ), .Q( TAP[1] ) );
dffr_2x_hv #(.ieIO("output"), .d2a_tr("100p"), .a2d_v0("0.5"), .d2a_tf("100p"),
 .a2d_v1("0.8"), .d2a_vh("2.5"), .a2d_tx("100p")) (*
integer
library_binding = "ether";
 *)
I19 ( .QN( TAP5b ), .D( TAP5b ), .RN(
RSTb ), .CK( IN[10] ), .Q( TAP[5] ) );
dffr_2x_hv #(.ieIO("output"), .d2a_tr("100p"), .a2d_v0("0.5"), .d2a_tf("100p"),
 .a2d_v1("0.8"), .d2a_vh("2.5"), .a2d_tx("100p")) (*
integer
library_binding = "ether";
 *)
I25 ( .QN( TAP[10] ), .D( TAP5b ), .RN(
RSTb ), .CK( IN[9] ), .Q( net012 ) );
dffr_2x_hv #(.ieIO("output"), .d2a_tr("100p"), .a2d_v0("0.5"), .d2a_tf("100p"),
 .a2d_tx("100p"), .d2a_vh("2.5"), .a2d_v1("0.8")) (*
integer
library_binding = "ether";
 *)
I26 ( .QN( TAP4b ), .D( TAP[10] ), .RN(
RSTb ), .CK( IN[8] ), .Q( TAP[4] ) );
dffr_2x_hv #(.d2a_tr("100p"), .ieIO("output"), .a2d_v0("0.5"), .d2a_tf("100p"),
 .a2d_v1("0.8"), .a2d_tx("100p"), .d2a_vh("2.5")) (*
integer
library_binding = "ether";
 *)
I29 ( .QN( TAP[8] ), .D( TAP3b ), .RN(
RSTb ), .CK( IN[5] ), .Q( net036 ) );
dffr_2x_hv #(.d2a_tr("100p"), .ieIO("output"), .a2d_v0("0.5"), .d2a_tf("100p"),
 .a2d_v1("0.8"), .a2d_tx("100p"), .d2a_vh("2.5")) (*
integer
library_binding = "ether";
 *)
I28 ( .QN( TAP3b ), .D( TAP[9] ), .RN(
RSTb ), .CK( IN[6] ), .Q( TAP[3] ) );
dffr_2x_hv #(.d2a_tr("100p"), .ieIO("output"), .a2d_v0("0.5"), .d2a_tf("100p"),
 .a2d_v1("0.8"), .a2d_tx("100p"), .d2a_vh("2.5")) (*
integer
library_binding = "ether";
 *)
I20 ( .QN( net51 ), .D( TAP[6] ), .RN(
RSTb ), .CK( IN[0] ), .Q( TAP[0] ) );
dffr_2x_hv #(.d2a_tr("100p"), .ieIO("output"), .a2d_v0("0.5"), .d2a_tf("100p"),
 .a2d_v1("0.8"), .a2d_tx("100p"), .d2a_vh("2.5")) (*
integer
library_binding = "ether";
 *)
I21 ( .QN( TAP[6] ), .D( TAP1b ), .RN(
RSTb ), .CK( IN[1] ), .Q( net48 ) );

endmodule
