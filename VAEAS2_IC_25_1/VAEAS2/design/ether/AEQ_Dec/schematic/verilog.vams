// Verilog-AMS netlist generated by the AMS netlister, version ICOA5.2.51.500.7.
// Cadence Design Systems, Inc.

`include "disciplines.vams"

module AEQ_Dec ( gain,pole,zero,agc_eq,timing_mode,agc_eq_bypass );

output [4:0]  gain;
output [1:0]  pole;
output [6:0]  zero;

input [4:0]  agc_eq;
input   timing_mode;
input   agc_eq_bypass;

wire n178;
wire n72;
wire n125;
wire n226;
wire n59;
wire n52;
wire n212;
wire n63;
wire n215;
wire n144;
wire n210;
wire n142;
wire n179;
wire n213;
wire n218;
wire n40;
wire n90;
wire n232;
wire n204;
wire n68;
wire n67;
wire n83;
wire n184;
wire n201;
wire n230;
wire n166;
wire n118;
wire n143;
wire n238;
wire n151;
wire n136;
wire n147;
wire n182;
wire n121;
wire n191;
wire n220;
wire n102;
wire n164;
wire n211;
wire n119;
wire n190;
wire n163;
wire n187;
wire n96;
wire [6:0] zero;
wire n181;
wire n228;
wire n130;
wire n140;
wire n112;
wire n115;
wire n200;
wire n134;
wire n124;
wire n152;
wire n153;
wire n185;
wire n217;
wire n55;
wire n199;
wire n51;
wire n120;
wire n128;
wire n84;
wire n158;
wire n85;
wire n141;
wire n49;
wire n61;
wire n214;
wire n79;
wire n223;
wire n135;
wire n202;
wire [4:0] gain;
wire n196;
wire n197;
wire n240;
wire n175;
wire n45;
wire n209;
wire n159;
wire n157;
wire n57;
wire n221;
wire n169;
wire n91;
wire n239;
wire n161;
wire n77;
wire n53;
wire n188;
wire n138;
wire n94;
wire [4:0] agc_eq;
wire n109;
wire n60;
wire n48;
wire n37;
wire n132;
wire n39;
wire n129;
wire n42;
wire n80;
wire n206;
wire n195;
wire n186;
wire n71;
wire n50;
wire n81;
wire n224;
wire n70;
wire n116;
wire n62;
wire n126;
wire n208;
wire n150;
wire n168;
wire n148;
wire n162;
wire n89;
wire n176;
wire n54;
wire n56;
wire n117;
wire n137;
wire n219;
wire n99;
wire n78;
wire n180;
wire [1:0] pole;
wire n113;
wire n41;
wire n43;
wire n36;
wire n160;
wire n167;
wire n146;
wire n233;
wire n156;
wire n111;
wire n207;
wire n133;
wire n92;
wire n58;
wire n236;
wire n64;
wire n105;
wire n192;
wire n122;
wire n177;
wire n205;
wire n114;
wire n198;
wire n189;
wire n127;
wire n231;
wire n203;
wire n139;
wire n73;
wire n47;
wire n106;
wire n74;
wire agc_eq_bypass;
wire n65;
wire n123;
wire n229;
wire n149;
wire n165;
wire n38;
wire n225;
wire n86;
wire n171;
wire n75;
wire n104;
wire n131;
wire n170;
wire n107;
wire n76;
wire n183;
wire n95;
wire timing_mode;
wire n88;
wire n44;
wire n145;
wire n110;
wire n108;
wire n98;
wire n103;

parameter tfall=0;
parameter tdel=0;
parameter trise=0;
parameter filename=0;
parameter Vlow=0;
parameter Vhigh=0;
parameter Vthr=0;

AOI32XL (*
integer library_binding = "gsclib090";
 *)
U292 ( .A0( n89 ),
.A1( n90 ), .B0( n91 ), .A2( n58 ), .Y( n70 ), .B1( n78 ) );

NAND2X1 (*
integer library_binding = "gsclib090";
 *)
U145 ( .Y( n153 ),
.B( n121 ), .A( n128 ) );
NAND2X1 (*
integer library_binding = "gsclib090";
 *)
U228 ( .Y( n213 ),
.B( n208 ), .A( n207 ) );
NAND2X1 (*
integer library_binding = "gsclib090";
 *)
U135 ( .Y( n148 ),
.B( n133 ), .A( n127 ) );
NAND2X1 (*
integer library_binding = "gsclib090";
 *)
U108 ( .Y( n122 ),
.B( n103 ), .A( n240 ) );
NAND2X1 (*
integer library_binding = "gsclib090";
 *)
U96 ( .Y( n107 ),
.B( n239 ), .A( n104 ) );
NAND2X1 (*
integer library_binding = "gsclib090";
 *)
U98 ( .Y( n106 ),
.B( n239 ), .A( n105 ) );
NAND2X1 (*
integer library_binding = "gsclib090";
 *)
U112 ( .Y( n80 ),
.B( n105 ), .A( n158 ) );
NAND2X1 (*
integer library_binding = "gsclib090";
 *)
U133 ( .Y( n147 ),
.B( n41 ), .A( n128 ) );
NAND2X1 (*
integer library_binding = "gsclib090";
 *)
U100 ( .Y( n118 ),
.B( n105 ), .A( n240 ) );
NAND2X1 (*
integer library_binding = "gsclib090";
 *)
U103 ( .Y( n129 ),
.B( n239 ), .A( n233 ) );
NAND2X1 (*
integer library_binding = "gsclib090";
 *)
U106 ( .Y( n64 ),
.B( n233 ), .A( n240 ) );
NAND2X1 (*
integer library_binding = "gsclib090";
 *)
U276 ( .Y( n71 ),
.B( n39 ), .A( n37 ) );
NAND2X1 (*
integer library_binding = "gsclib090";
 *)
U116 ( .Y( n54 ),
.B( n233 ), .A( n158 ) );
NAND2X1 (*
integer library_binding = "gsclib090";
 *)
U111 ( .Y( n67 ),
.B( n104 ), .A( n158 ) );
NAND2X1 (*
integer library_binding = "gsclib090";
 *)
U164 ( .Y( n83 ),
.B( n163 ), .A( n162 ) );
NAND2X1 (*
integer library_binding = "gsclib090";
 *)
U251 ( .Y( n226 ),
.B( n113 ), .A( n112 ) );
NAND2X1 (*
integer library_binding = "gsclib090";
 *)
U137 ( .Y( n127 ),
.B( n167 ), .A( n105 ) );
NAND2X1 (*
integer library_binding = "gsclib090";
 *)
U99 ( .Y( n135 ),
.B( n99 ), .A( n240 ) );
NAND2X1 (*
integer library_binding = "gsclib090";
 *)
U227 ( .Y( n206 ),
.B( n212 ), .A( n211 ) );
NAND2X1 (*
integer library_binding = "gsclib090";
 *)
U109 ( .Y( n121 ),
.B( n88 ), .A( n240 ) );
NAND2X1 (*
integer library_binding = "gsclib090";
 *)
U175 ( .Y( n109 ),
.B( n99 ), .A( n167 ) );
NAND2X1 (*
integer library_binding = "gsclib090";
 *)
U115 ( .Y( n81 ),
.B( n103 ), .A( n158 ) );
NAND2X1 (*
integer library_binding = "gsclib090";
 *)
U230 ( .Y( n214 ),
.B( n210 ), .A( n209 ) );
NAND2X1 (*
integer library_binding = "gsclib090";
 *)
U168 ( .Y( n166 ),
.B( n164 ), .A( n122 ) );

NAND2XL (*
integer library_binding = "gsclib090";
 *)
U286 ( .Y( n68 ),
.B( n99 ), .A( n158 ) );
NAND2XL (*
integer library_binding = "gsclib090";
 *)
U166 ( .Y( n165 ),
.B( n130 ), .A( n65 ) );
NAND2XL (*
integer library_binding = "gsclib090";
 *)
U255 ( .Y( n110 ),
.B( n167 ), .A( n104 ) );
NAND2XL (*
integer library_binding = "gsclib090";
 *)
U256 ( .Y( n111 ),
.B( n88 ), .A( n167 ) );
NAND2XL (*
integer library_binding = "gsclib090";
 *)
U177 ( .Y(
pole[1] ), .B( n169 ), .A( n168 ) );
NAND2XL (*
integer library_binding = "gsclib090";
 *)
U193 ( .Y(
zero[1] ), .B( n182 ), .A( n181 ) );
NAND2XL (*
integer library_binding = "gsclib090";
 *)
U268 ( .Y( n136 ),
.B( n229 ), .A( n228 ) );
NAND2XL (*
integer library_binding = "gsclib090";
 *)
U191 ( .Y( n176 ),
.B( n180 ), .A( n179 ) );
NAND2XL (*
integer library_binding = "gsclib090";
 *)
U284 ( .Y( n113 ),
.B( n167 ), .A( n103 ) );
NAND2XL (*
integer library_binding = "gsclib090";
 *)
U190 ( .Y( n175 ),
.B( n178 ), .A( n177 ) );
NAND2XL (*
integer library_binding = "gsclib090";
 *)
U287 ( .Y( n141 ),
.B( n102 ), .A( n158 ) );
NAND2XL (*
integer library_binding = "gsclib090";
 *)
U265 ( .Y( n120 ),
.B( n239 ), .A( n114 ) );
NAND2XL (*
integer library_binding = "gsclib090";
 *)
U132 ( .Y( n57 ),
.B( n146 ), .A( n145 ) );
NAND2XL (*
integer library_binding = "gsclib090";
 *)
U266 ( .Y( n116 ),
.B( n167 ), .A( n114 ) );
NAND2XL (*
integer library_binding = "gsclib090";
 *)
U235 ( .Y(
gain[1] ), .B( n218 ), .A( n217 ) );
NAND2XL (*
integer library_binding = "gsclib090";
 *)
U271 ( .Y( n229 ),
.B( n89 ), .A( n230 ) );
NAND2XL (*
integer library_binding = "gsclib090";
 *)
U208 ( .Y( n188 ),
.B( n192 ), .A( n191 ) );
NAND2XL (*
integer library_binding = "gsclib090";
 *)
U248 ( .Y( n86 ),
.B( n224 ), .A( n223 ) );
NAND2XL (*
integer library_binding = "gsclib090";
 *)
U249 ( .Y( n225 ),
.B( n111 ), .A( n110 ) );
NAND2XL (*
integer library_binding = "gsclib090";
 *)
U240 ( .Y( n218 ),
.B( n221 ), .A( n219 ) );
NAND2XL (*
integer library_binding = "gsclib090";
 *)
U283 ( .Y( n108 ),
.B( n239 ), .A( n103 ) );
NAND2XL (*
integer library_binding = "gsclib090";
 *)
U155 ( .Y(
gain[0] ), .B( n157 ), .A( n156 ) );
NAND2XL (*
integer library_binding = "gsclib090";
 *)
U259 ( .Y( n117 ),
.B( n239 ), .A( n99 ) );
NAND2XL (*
integer library_binding = "gsclib090";
 *)
U246 ( .Y( n126 ),
.B( n167 ), .A( n102 ) );
NAND2XL (*
integer library_binding = "gsclib090";
 *)
U278 ( .Y( n91 ),
.B( n48 ), .A( n236 ) );
NAND2XL (*
integer library_binding = "gsclib090";
 *)
U198 ( .Y( n181 ),
.B( n184 ), .A( n183 ) );
NAND2XL (*
integer library_binding = "gsclib090";
 *)
U140 ( .Y( n74 ),
.B( n78 ), .A( n90 ) );
NAND2XL (*
integer library_binding = "gsclib090";
 *)
U239 ( .Y( n217 ),
.B( n220 ), .A( n219 ) );
NAND2XL (*
integer library_binding = "gsclib090";
 *)
U160 ( .Y( n156 ),
.B( n159 ), .A( n158 ) );
NAND2XL (*
integer library_binding = "gsclib090";
 *)
U207 ( .Y( n187 ),
.B( n190 ), .A( n189 ) );
NAND2XL (*
integer library_binding = "gsclib090";
 *)
U244 ( .Y( n65 ),
.B( n102 ), .A( n240 ) );
NAND2XL (*
integer library_binding = "gsclib090";
 *)
U185 ( .Y(
zero[2] ), .B( n176 ), .A( n175 ) );
NAND2XL (*
integer library_binding = "gsclib090";
 *)
U173 ( .Y( n123 ),
.B( n88 ), .A( n239 ) );
NAND2XL (*
integer library_binding = "gsclib090";
 *)
U270 ( .Y( n228 ),
.B( agc_eq[1] ), .A( n230 ) );
NAND2XL (*
integer library_binding = "gsclib090";
 *)
U180 ( .Y( n168 ),
.B( n58 ), .A( n57 ) );
NAND2XL (*
integer library_binding = "gsclib090";
 *)
U202 ( .Y(
zero[3] ), .B( n188 ), .A( n187 ) );
NAND2XL (*
integer library_binding = "gsclib090";
 *)
U161 ( .Y( n157 ),
.B( n161 ), .A( n160 ) );
NAND2XL (*
integer library_binding = "gsclib090";
 *)
U144 ( .Y( n76 ),
.B( n152 ), .A( n130 ) );
NAND2XL (*
integer library_binding = "gsclib090";
 *)
U245 ( .Y( n133 ),
.B( n239 ), .A( n102 ) );
NAND2XL (*
integer library_binding = "gsclib090";
 *)
U199 ( .Y( n182 ),
.B( n186 ), .A( n185 ) );
NAND2XL (*
integer library_binding = "gsclib090";
 *)
U181 ( .Y( n169 ),
.B( n171 ), .A( n170 ) );

AND4XL (*
integer library_binding = "gsclib090";
 *)
U69 ( .D( n68 ),
.C( n131 ), .Y( n130 ), .B( n124 ), .A( n61 ) );
AND4XL (*
integer library_binding = "gsclib090";
 *)
U147 ( .D( n123 ),
.C( n117 ), .Y( n128 ), .B( n129 ), .A( n120 ) );
AND4XL (*
integer library_binding = "gsclib090";
 *)
U60 ( .D( n119 ),
.C( n118 ), .Y( n53 ), .B( n111 ), .A( n117 ) );
AND4XL (*
integer library_binding = "gsclib090";
 *)
U61 ( .D( n123 ),
.C( n122 ), .Y( n62 ), .B( n121 ), .A( n120 ) );
AND4XL (*
integer library_binding = "gsclib090";
 *)
U56 ( .D( n109 ),
.C( n108 ), .Y( n41 ), .B( n107 ), .A( n106 ) );
AND4XL (*
integer library_binding = "gsclib090";
 *)
U75 ( .D( n135 ),
.C( n134 ), .Y( n44 ), .B( n129 ), .A( n53 ) );

AND2X1 (*
integer library_binding = "gsclib090";
 *)
U81 ( .Y( n134 ),
.B( n107 ), .A( n110 ) );
AND2X1 (*
integer library_binding = "gsclib090";
 *)
U79 ( .Y( n42 ),
.B( n117 ), .A( n123 ) );
AND2X1 (*
integer library_binding = "gsclib090";
 *)
U222 ( .Y( n204 ),
.B( n88 ), .A( n158 ) );
AND2X1 (*
integer library_binding = "gsclib090";
 *)
U82 ( .Y( n125 ),
.B( n133 ), .A( n113 ) );
AND2X1 (*
integer library_binding = "gsclib090";
 *)
U83 ( .Y( n131 ),
.B( n118 ), .A( n110 ) );
AND2X1 (*
integer library_binding = "gsclib090";
 *)
U41 ( .Y( n92 ),
.B( n94 ), .A( n240 ) );
AND2X1 (*
integer library_binding = "gsclib090";
 *)
U129 ( .Y( n143 ),
.B( n36 ), .A( n231 ) );

AND3X2 (*
integer library_binding = "gsclib090";
 *)
U85 ( .C( n108 ),
.Y( n55 ), .B( n126 ), .A( n120 ) );
AND3X2 (*
integer library_binding = "gsclib090";
 *)
U143 ( .C( n127 ),
.Y( n61 ), .B( n126 ), .A( n113 ) );

OAI2BB1X1 (*
integer library_binding = "gsclib090";
 *)
U73 ( .A0N(
n114 ), .A1N( n158 ), .B0( n54 ), .Y( n84 ) );
OAI2BB1X1 (*
integer library_binding = "gsclib090";
 *)
U64 ( .A0N(
n240 ), .A1N( n114 ), .B0( n64 ), .Y( n73 ) );

NOR2BX1 (*
integer library_binding = "gsclib090";
 *)
U78 ( .AN( n126 ),
.Y( n112 ), .B( n139 ) );

CLKINVX1 (*
integer library_binding = "gsclib090";
 *)
U250 ( .Y( n223 ),
.A( n225 ) );
CLKINVX1 (*
integer library_binding = "gsclib090";
 *)
U205 ( .Y( n191 ),
.A( n236 ) );
CLKINVX1 (*
integer library_binding = "gsclib090";
 *)
U213 ( .Y( n197 ),
.A( n44 ) );
CLKINVX1 (*
integer library_binding = "gsclib090";
 *)
U212 ( .Y( n196 ),
.A( n63 ) );
CLKINVX1 (*
integer library_binding = "gsclib090";
 *)
U203 ( .Y( n189 ),
.A( n48 ) );
CLKINVX1 (*
integer library_binding = "gsclib090";
 *)
U165 ( .Y( n164 ),
.A( n132 ) );
CLKINVX1 (*
integer library_binding = "gsclib090";
 *)
U238 ( .Y( n221 ),
.A( n67 ) );
CLKINVX1 (*
integer library_binding = "gsclib090";
 *)
U134 ( .Y( n145 ),
.A( n147 ) );
CLKINVX1 (*
integer library_binding = "gsclib090";
 *)
U229 ( .Y( n211 ),
.A( n213 ) );
CLKINVX1 (*
integer library_binding = "gsclib090";
 *)
U159 ( .Y( n161 ),
.A( n205 ) );
CLKINVX1 (*
integer library_binding = "gsclib090";
 *)
U139 ( .Y( n150 ),
.A( n149 ) );
CLKINVX1 (*
integer library_binding = "gsclib090";
 *)
U102 ( .Y( n142 ),
.A( n116 ) );
CLKINVX1 (*
integer library_binding = "gsclib090";
 *)
U169 ( .Y( n163 ),
.A( n166 ) );
CLKINVX1 (*
integer library_binding = "gsclib090";
 *)
U126 ( .Y( n75 ),
.A( n240 ) );
CLKINVX1 (*
integer library_binding = "gsclib090";
 *)
U170 ( .Y( n79 ),
.A( n83 ) );
CLKINVX1 (*
integer library_binding = "gsclib090";
 *)
U223 ( .Y( n59 ),
.A( n206 ) );
CLKINVX1 (*
integer library_binding = "gsclib090";
 *)
U225 ( .Y( n208 ),
.A( n86 ) );
CLKINVX1 (*
integer library_binding = "gsclib090";
 *)
U214 ( .Y( n198 ),
.A( n62 ) );
CLKINVX1 (*
integer library_binding = "gsclib090";
 *)
U188 ( .Y( n179 ),
.A( n236 ) );
CLKINVX1 (*
integer library_binding = "gsclib090";
 *)
U194 ( .Y( n183 ),
.A( n48 ) );
CLKINVX1 (*
integer library_binding = "gsclib090";
 *)
U141 ( .Y( n151 ),
.A( n209 ) );
CLKINVX1 (*
integer library_binding = "gsclib090";
 *)
U196 ( .Y( n185 ),
.A( n236 ) );
CLKINVX1 (*
integer library_binding = "gsclib090";
 *)
U167 ( .Y( n162 ),
.A( n165 ) );
CLKINVX1 (*
integer library_binding = "gsclib090";
 *)
U204 ( .Y( n190 ),
.A( n47 ) );
CLKINVX1 (*
integer library_binding = "gsclib090";
 *)
U254 ( .Y( n40 ),
.A( n86 ) );
CLKINVX1 (*
integer library_binding = "gsclib090";
 *)
U189 ( .Y( n180 ),
.A( n49 ) );
CLKINVX1 (*
integer library_binding = "gsclib090";
 *)
U231 ( .Y( n212 ),
.A( n214 ) );
CLKINVX1 (*
integer library_binding = "gsclib090";
 *)
U215 ( .Y( n199 ),
.A( n61 ) );
CLKINVX1 (*
integer library_binding = "gsclib090";
 *)
U178 ( .Y( n170 ),
.A( n236 ) );
CLKINVX1 (*
integer library_binding = "gsclib090";
 *)
U226 ( .Y( n210 ),
.A( n85 ) );
CLKINVX1 (*
integer library_binding = "gsclib090";
 *)
U220 ( .Y( n201 ),
.A( n203 ) );
CLKINVX1 (*
integer library_binding = "gsclib090";
 *)
U105 ( .Y( n140 ),
.A( n133 ) );
CLKINVX1 (*
integer library_binding = "gsclib090";
 *)
U224 ( .Y( n207 ),
.A( n73 ) );
CLKINVX1 (*
integer library_binding = "gsclib090";
 *)
U186 ( .Y( n177 ),
.A( n48 ) );
CLKINVX1 (*
integer library_binding = "gsclib090";
 *)
U195 ( .Y( n184 ),
.A( n52 ) );
CLKINVX1 (*
integer library_binding = "gsclib090";
 *)
U158 ( .Y( n160 ),
.A( n236 ) );

NAND3BXL (*
integer library_binding = "gsclib090";
 *)
U171 ( .AN(
n139 ), .C( n111 ), .Y( n132 ), .B( n135 ) );

INVXL (*
integer library_binding = "gsclib090";
 *)
U206 ( .Y( n192 ),
.A( n45 ) );
INVXL (*
integer library_binding = "gsclib090";
 *)
U237 ( .Y( n220 ),
.A( n68 ) );
INVXL (*
integer library_binding = "gsclib090";
 *)
U128 ( .Y( n89 ),
.A( agc_eq[0] ) );
INVXL (*
integer library_binding = "gsclib090";
 *)
U131 ( .Y( n137 ),
.A( n144 ) );
INVXL (*
integer library_binding = "gsclib090";
 *)
U136 ( .Y( n146 ),
.A( n148 ) );
INVXL (*
integer library_binding = "gsclib090";
 *)
U146 ( .Y( n152 ),
.A( n153 ) );
INVXL (*
integer library_binding = "gsclib090";
 *)
U176 ( .Y( n39 ),
.A( agc_eq[4] ) );
INVXL (*
integer library_binding = "gsclib090";
 *)
U296 ( .Y( n78 ),
.A( agc_eq[2] ) );
INVXL (*
integer library_binding = "gsclib090";
 *)
U130 ( .Y( n144 ),
.A( n143 ) );
INVXL (*
integer library_binding = "gsclib090";
 *)
U269 ( .Y( n230 ),
.A( n98 ) );
INVXL (*
integer library_binding = "gsclib090";
 *)
U148 ( .Y( n231 ),
.A( n90 ) );
INVXL (*
integer library_binding = "gsclib090";
 *)
U154 ( .Y( n37 ),
.A( agc_eq[3] ) );
INVXL (*
integer library_binding = "gsclib090";
 *)
U262 ( .Y( n36 ),
.A( n89 ) );
INVXL (*
integer library_binding = "gsclib090";
 *)
U274 ( .Y( n233 ),
.A( n232 ) );
INVXL (*
integer library_binding = "gsclib090";
 *)
U157 ( .Y( n159 ),
.A( n70 ) );
INVXL (*
integer library_binding = "gsclib090";
 *)
U236 ( .Y( n219 ),
.A( n43 ) );
INVXL (*
integer library_binding = "gsclib090";
 *)
U197 ( .Y( n186 ),
.A( n51 ) );
INVXL (*
integer library_binding = "gsclib090";
 *)
U300 ( .Y( n239 ),
.A( n238 ) );
INVXL (*
integer library_binding = "gsclib090";
 *)
U162 ( .Y( n205 ),
.A( n204 ) );
INVXL (*
integer library_binding = "gsclib090";
 *)
U280 ( .Y( n58 ),
.A( n48 ) );
INVXL (*
integer library_binding = "gsclib090";
 *)
U152 ( .Y( n124 ),
.A( n115 ) );
INVXL (*
integer library_binding = "gsclib090";
 *)
U142 ( .Y( n209 ),
.A( n77 ) );
INVXL (*
integer library_binding = "gsclib090";
 *)
U252 ( .Y( n224 ),
.A( n226 ) );
INVXL (*
integer library_binding = "gsclib090";
 *)
U149 ( .Y( n90 ),
.A( agc_eq[1] ) );
INVXL (*
integer library_binding = "gsclib090";
 *)
U234 ( .Y( gain[2] ),
.A( n215 ) );
INVXL (*
integer library_binding = "gsclib090";
 *)
U211 ( .Y( gain[4] ),
.A( n195 ) );
INVXL (*
integer library_binding = "gsclib090";
 *)
U156 ( .Y( n158 ),
.A( n71 ) );

AOI31XL (*
integer library_binding = "gsclib090";
 *)
U242 ( .A0( n53 ),
.A1( n54 ), .B0( n43 ), .Y( zero[0] ), .A2( n55 ) );
AOI31XL (*
integer library_binding = "gsclib090";
 *)
U243 ( .A0( n40 ),
.A1( n41 ), .B0( n43 ), .Y( zero[5] ), .A2( n42 ) );

AOI211XL (*
integer library_binding = "gsclib090";
 *)
U302 ( .C0(
n140 ), .A0( n240 ), .A1( n104 ), .B0( n115 ), .Y( n119 ) );
AOI211XL (*
integer library_binding = "gsclib090";
 *)
U257 ( .C0(
agc_eq_bypass ), .A0( n37 ), .A1( n38 ), .B0( n39 ), .Y( zero[6] ) );

NAND3XL (*
integer library_binding = "gsclib090";
 *)
U151 ( .C( n116 ),
.Y( n115 ), .B( n109 ), .A( n106 ) );

NAND4X1 (*
integer library_binding = "gsclib090";
 *)
U86 ( .D( n116 ),
.C( n68 ), .Y( n85 ), .B( n81 ), .A( n141 ) );

NOR2X1 (*
integer library_binding = "gsclib090";
 *)
U219 ( .Y( n203 ),
.B( n199 ), .A( n198 ) );
NOR2X1 (*
integer library_binding = "gsclib090";
 *)
U33 ( .Y( n49 ),
.B( n151 ), .A( n76 ) );
NOR2X1 (*
integer library_binding = "gsclib090";
 *)
U42 ( .Y( n95 ),
.B( n71 ), .A( n94 ) );
NOR2X1 (*
integer library_binding = "gsclib090";
 *)
U31 ( .Y( n45 ),
.B( n73 ), .A( n72 ) );
NOR2X1 (*
integer library_binding = "gsclib090";
 *)
U301 ( .Y( n240 ),
.B( agc_eq[4] ), .A( n37 ) );
NOR2X1 (*
integer library_binding = "gsclib090";
 *)
U37 ( .Y( n56 ),
.B( n57 ), .A( n84 ) );
NOR2X1 (*
integer library_binding = "gsclib090";
 *)
U217 ( .Y( n202 ),
.B( n197 ), .A( n196 ) );

INVX1 (*
integer library_binding = "gsclib090";
 *)
U179 ( .Y( n171 ),
.A( n56 ) );
INVX1 (*
integer library_binding = "gsclib090";
 *)
U218 ( .Y( n200 ),
.A( n202 ) );
INVX1 (*
integer library_binding = "gsclib090";
 *)
U187 ( .Y( n178 ),
.A( n50 ) );

OAI21XL (*
integer library_binding = "gsclib090";
 *)
U289 ( .A0( n59 ),
.A1( n236 ), .B0( n60 ), .Y( pole[0] ) );

OAI31XL (*
integer library_binding = "gsclib090";
 *)
U253 ( .A0( n84 ),
.A1( n142 ), .B0( n58 ), .Y( n60 ), .A2( n86 ) );

AOI21X1 (*
integer library_binding = "gsclib090";
 *)
U28 ( .A0( n64 ),
.A1( n65 ), .B0( n43 ), .Y( gain[3] ) );

NOR2XL (*
integer library_binding = "gsclib090";
 *)
U174 ( .Y( n167 ),
.B( agc_eq[3] ), .A( n39 ) );
NOR2XL (*
integer library_binding = "gsclib090";
 *)
U216 ( .Y( n195 ),
.B( n201 ), .A( n200 ) );
NOR2XL (*
integer library_binding = "gsclib090";
 *)
U294 ( .Y( n105 ),
.B( n78 ), .A( n144 ) );
NOR2XL (*
integer library_binding = "gsclib090";
 *)
U232 ( .Y(
zero[4] ), .B( n44 ), .A( n43 ) );
NOR2XL (*
integer library_binding = "gsclib090";
 *)
U285 ( .Y( n103 ),
.B( agc_eq[2] ), .A( n144 ) );
NOR2XL (*
integer library_binding = "gsclib090";
 *)
U264 ( .Y( n98 ),
.B( n36 ), .A( n90 ) );
NOR2XL (*
integer library_binding = "gsclib090";
 *)
U267 ( .Y( n114 ),
.B( n36 ), .A( n74 ) );
NOR2XL (*
integer library_binding = "gsclib090";
 *)
U293 ( .Y( n96 ),
.B( n231 ), .A( n78 ) );

MXI2XL (*
integer library_binding = "gsclib090";
 *)
U295 ( .Y( n138 ),
.S0( n136 ), .B( agc_eq[2] ), .A( n78 ) );

AND2XL (*
integer library_binding = "gsclib090";
 *)
U260 ( .Y( n99 ),
.B( agc_eq[2] ), .A( n98 ) );
AND2XL (*
integer library_binding = "gsclib090";
 *)
U261 ( .Y( n88 ),
.B( n89 ), .A( n96 ) );
AND2XL (*
integer library_binding = "gsclib090";
 *)
U279 ( .Y( n43 ),
.B( n48 ), .A( n236 ) );
AND2XL (*
integer library_binding = "gsclib090";
 *)
U247 ( .Y( n102 ),
.B( n78 ), .A( n98 ) );

OR2XL (*
integer library_binding = "gsclib090";
 *)
U233 ( .Y( n215 ),
.B( n150 ), .A( agc_eq_bypass ) );
OR2XL (*
integer library_binding = "gsclib090";
 *)
U299 ( .Y( n238 ),
.B( n39 ), .A( n37 ) );
OR2XL (*
integer library_binding = "gsclib090";
 *)
U163 ( .Y( n236 ),
.B( agc_eq_bypass ), .A( timing_mode ) );

NAND2BXL (*
integer library_binding = "gsclib090";
 *)
U281 ( .AN(
agc_eq_bypass ), .Y( n48 ), .B( timing_mode ) );

OR2X1 (*
integer library_binding = "gsclib090";
 *)
U119 ( .Y( n38 ),
.B( n94 ), .A( n138 ) );
OR2X1 (*
integer library_binding = "gsclib090";
 *)
U273 ( .Y( n232 ),
.B( n89 ), .A( n74 ) );

AOI2BB1XL (*
integer library_binding = "gsclib090";
 *)
U272 ( .A0N(
n136 ), .A1N( n78 ), .B0( n137 ), .Y( n94 ) );

AND2X2 (*
integer library_binding = "gsclib090";
 *)
U263 ( .Y( n104 ),
.B( n36 ), .A( n96 ) );
AND2X2 (*
integer library_binding = "gsclib090";
 *)
U275 ( .Y( n139 ),
.B( n233 ), .A( n167 ) );

AOI2BB1X1 (*
integer library_binding = "gsclib090";
 *)
U192 ( .A0N(
n78 ), .A1N( n71 ), .B0( n76 ), .Y( n50 ) );
AOI2BB1X1 (*
integer library_binding = "gsclib090";
 *)
U201 ( .A0N(
n144 ), .A1N( n71 ), .B0( n83 ), .Y( n52 ) );
AOI2BB1X1 (*
integer library_binding = "gsclib090";
 *)
U32 ( .A0N(
n74 ), .A1N( n75 ), .B0( n72 ), .Y( n47 ) );

AND3XL (*
integer library_binding = "gsclib090";
 *)
U200 ( .C( n81 ),
.Y( n51 ), .B( n80 ), .A( n79 ) );

NAND3X1 (*
integer library_binding = "gsclib090";
 *)
U71 ( .C( n80 ),
.Y( n77 ), .B( n205 ), .A( n67 ) );

NAND4XL (*
integer library_binding = "gsclib090";
 *)
U172 ( .D( n65 ),
.C( n125 ), .Y( n72 ), .B( n124 ), .A( n62 ) );

NOR3BXL (*
integer library_binding = "gsclib090";
 *)
U221 ( .AN( n108 ),
.C( n139 ), .Y( n63 ), .B( agc_eq_bypass ) );

MX2X1 (*
integer library_binding = "gsclib090";
 *)
U138 ( .Y( n149 ),
.S0( n138 ), .B( n92 ), .A( n95 ) );

endmodule
