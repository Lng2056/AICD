// Verilog-AMS netlist generated by the AMS netlister, version ICOA5.2.51.500.7.
// Cadence Design Systems, Inc.

`include "disciplines.vams"

module PLL_VCO_320MHZ ( IEXT_100u,VDD,PD,VCO_CLK,Vcontrol,VSS );

input   IEXT_100u;
input   VDD;
input   PD;
output   VCO_CLK;
input
 Vcontrol;
input   VSS;

capacitor #(.c(15f)) (*
integer library_binding = "analogLib";
 *)
C29
 ( INV_7_P, VSS );
capacitor #(.c(15f)) (*
integer library_binding = "analogLib";
 *)
C42
 ( INV_7_N, VSS );
capacitor #(.c(15f)) (*
integer library_binding = "analogLib";
 *)
C27
 ( INV_1_P, VSS );
capacitor #(.c(15f)) (*
integer library_binding = "analogLib";
 *)
C41
 ( INV_9_P, VSS );
capacitor #(.c(15f)) (*
integer library_binding = "analogLib";
 *)
C37
 ( INV_10_N, VSS );
capacitor #(.c(15f)) (*
integer library_binding = "analogLib";
 *)
C38
 ( INV_9_N, VSS );
capacitor #(.c(15f)) (*
integer library_binding = "analogLib";
 *)
C34
 ( INV_4_P, VSS );
capacitor #(.c(15f)) (*
integer library_binding = "analogLib";
 *)
C45
 ( INV_4_N, VSS );
capacitor #(.c(15f)) (*
integer library_binding = "analogLib";
 *)
C35
 ( INV_3_P, VSS );
capacitor #(.c(20f)) (*
integer library_binding = "analogLib";
 *)
C28
 ( INV_11_N, VSS );
capacitor #(.c(20f)) (*
integer library_binding = "analogLib";
 *)
C40
 ( INV_11_P, VSS );
capacitor #(.c(15f)) (*
integer library_binding = "analogLib";
 *)
C25
 ( INV_10_P, VSS );
capacitor #(.c(15f)) (*
integer library_binding = "analogLib";
 *)
C26
 ( INV_2_P, VSS );
capacitor #(.c(15f)) (*
integer library_binding = "analogLib";
 *)
C33
 ( INV_2_N, VSS );
capacitor #(.c(15f)) (*
integer library_binding = "analogLib";
 *)
C44
 ( INV_5_N, VSS );
capacitor #(.c(15f)) (*
integer library_binding = "analogLib";
 *)
C36
 ( INV_5_P, VSS );
capacitor #(.c(15f)) (*
integer library_binding = "analogLib";
 *)
C39
 ( INV_6_N, VSS );
capacitor #(.c(60f)) (*
integer library_binding = "analogLib";
 *)
C23
 ( VCO_CLK, VSS );
capacitor #(.c(15f)) (*
integer library_binding = "analogLib";
 *)
C24
 ( INV_8_N, VSS );
capacitor #(.c(15f)) (*
integer library_binding = "analogLib";
 *)
C32
 ( INV_1_N, VSS );
capacitor #(.c(15f)) (*
integer library_binding = "analogLib";
 *)
C31
 ( INV_8_P, VSS );
capacitor #(.c(15f)) (*
integer library_binding = "analogLib";
 *)
C30
 ( INV_3_N, VSS );
capacitor #(.c(15f)) (*
integer library_binding = "analogLib";
 *)
C43
 ( INV_6_P, VSS );

PLL_VCO_REG (*
integer library_binding = "ether";
 *)
I62 ( .IEXT_100u(
IEXT_100u ), .VFB( Vring ), .VDD( VDD ), .PD( PD ), .VSS( VSS ), .Vcontrol(
Vcontrol ), .VRING( Vring ) );

PLL_VCO_CMOSDVR (*
integer library_binding = "ether";
 *)
I46 ( .INn(
INV_11_P ), .VDD( VDD ), .INp( INV_11_N ), .PD( PD ), .OUT( VCO_CLK ),
.VSS( VSS ) );

PLL_VCO_320MHZ_INV (*
integer library_binding = "ether";
 *)
INVN6 ( .VDD(
Vring ), .Y( INV_6_N ), .VSS( VSS ), .A( INV_5_N ) );
PLL_VCO_320MHZ_INV (*
integer library_binding = "ether";
 *)
INVN7 ( .VDD(
Vring ), .Y( INV_7_N ), .VSS( VSS ), .A( INV_6_N ) );
PLL_VCO_320MHZ_INV (*
integer library_binding = "ether";
 *)
INVN8 ( .VDD(
Vring ), .Y( INV_8_N ), .VSS( VSS ), .A( INV_7_N ) );
PLL_VCO_320MHZ_INV (*
integer library_binding = "ether";
 *)
INVP1 ( .VDD(
Vring ), .Y( INV_1_P ), .VSS( VSS ), .A( INV_11_P ) );
PLL_VCO_320MHZ_INV (*
integer library_binding = "ether";
 *)
INVP11 (
.VDD( Vring ), .Y( INV_11_P ), .VSS( VSS ), .A( INV_10_P ) );
PLL_VCO_320MHZ_INV (*
integer library_binding = "ether";
 *)
INVN4 ( .VDD(
Vring ), .Y( INV_4_N ), .VSS( VSS ), .A( INV_3_N ) );
PLL_VCO_320MHZ_INV (*
integer library_binding = "ether";
 *)
INVP3 ( .VDD(
Vring ), .Y( INV_3_P ), .VSS( VSS ), .A( INV_2_P ) );
PLL_VCO_320MHZ_INV (*
integer library_binding = "ether";
 *)
INVP5 ( .VDD(
Vring ), .Y( INV_5_P ), .VSS( VSS ), .A( INV_4_P ) );
PLL_VCO_320MHZ_INV (*
integer library_binding = "ether";
 *)
INVP9 ( .VDD(
Vring ), .Y( INV_9_P ), .VSS( VSS ), .A( INV_8_P ) );
PLL_VCO_320MHZ_INV (*
integer library_binding = "ether";
 *)
INVN2 ( .VDD(
Vring ), .Y( INV_2_N ), .VSS( VSS ), .A( INV_1_N ) );
PLL_VCO_320MHZ_INV (*
integer library_binding = "ether";
 *)
INVN10 (
.VDD( Vring ), .Y( INV_10_N ), .VSS( VSS ), .A( INV_9_N ) );
PLL_VCO_320MHZ_INV (*
integer library_binding = "ether";
 *)
INVP6 ( .VDD(
Vring ), .Y( INV_6_P ), .VSS( VSS ), .A( INV_5_P ) );
PLL_VCO_320MHZ_INV (*
integer library_binding = "ether";
 *)
INVN1 ( .VDD(
Vring ), .Y( INV_1_N ), .VSS( VSS ), .A( INV_11_N ) );
PLL_VCO_320MHZ_INV (*
integer library_binding = "ether";
 *)
INVN3 ( .VDD(
Vring ), .Y( INV_3_N ), .VSS( VSS ), .A( INV_2_N ) );
PLL_VCO_320MHZ_INV (*
integer library_binding = "ether";
 *)
INVN5 ( .VDD(
Vring ), .Y( INV_5_N ), .VSS( VSS ), .A( INV_4_N ) );
PLL_VCO_320MHZ_INV (*
integer library_binding = "ether";
 *)
INVP4 ( .VDD(
Vring ), .Y( INV_4_P ), .VSS( VSS ), .A( INV_3_P ) );
PLL_VCO_320MHZ_INV (*
integer library_binding = "ether";
 *)
INVP2 ( .VDD(
Vring ), .Y( INV_2_P ), .VSS( VSS ), .A( INV_1_P ) );
PLL_VCO_320MHZ_INV (*
integer library_binding = "ether";
 *)
INVP7 ( .VDD(
Vring ), .Y( INV_7_P ), .VSS( VSS ), .A( INV_6_P ) );
PLL_VCO_320MHZ_INV (*
integer library_binding = "ether";
 *)
INVP8 ( .VDD(
Vring ), .Y( INV_8_P ), .VSS( VSS ), .A( INV_7_P ) );
PLL_VCO_320MHZ_INV (*
integer library_binding = "ether";
 *)
INVN9 ( .VDD(
Vring ), .Y( INV_9_N ), .VSS( VSS ), .A( INV_8_N ) );
PLL_VCO_320MHZ_INV (*
integer library_binding = "ether";
 *)
INVP10 (
.VDD( Vring ), .Y( INV_10_P ), .VSS( VSS ), .A( INV_9_P ) );
PLL_VCO_320MHZ_INV (*
integer library_binding = "ether";
 *)
INVN11 (
.VDD( Vring ), .Y( INV_11_N ), .VSS( VSS ), .A( INV_10_N ) );

PLL_VCO_INV (*
integer library_binding = "ether";
 *)
INVC5 ( .VDD(
Vring ), .Y( INV_5_N ), .VSS( VSS ), .A( INV_5_P ) );
PLL_VCO_INV (*
integer library_binding = "ether";
 *)
INVC7 ( .VDD(
Vring ), .Y( INV_7_N ), .VSS( VSS ), .A( INV_7_P ) );
PLL_VCO_INV (*
integer library_binding = "ether";
 *)
INVC10 ( .VDD(
Vring ), .Y( INV_10_P ), .VSS( VSS ), .A( INV_10_N ) );
PLL_VCO_INV (*
integer library_binding = "ether";
 *)
INVC1 ( .VDD(
Vring ), .Y( INV_1_N ), .VSS( VSS ), .A( INV_1_P ) );
PLL_VCO_INV (*
integer library_binding = "ether";
 *)
INVC3 ( .VDD(
Vring ), .Y( INV_3_N ), .VSS( VSS ), .A( INV_3_P ) );
PLL_VCO_INV (*
integer library_binding = "ether";
 *)
INVC4 ( .VDD(
Vring ), .Y( INV_4_P ), .VSS( VSS ), .A( INV_4_N ) );
PLL_VCO_INV (*
integer library_binding = "ether";
 *)
INVC2 ( .VDD(
Vring ), .Y( INV_2_P ), .VSS( VSS ), .A( INV_2_N ) );
PLL_VCO_INV (*
integer library_binding = "ether";
 *)
INVC6 ( .VDD(
Vring ), .Y( INV_6_P ), .VSS( VSS ), .A( INV_6_N ) );
PLL_VCO_INV (*
integer library_binding = "ether";
 *)
INVC8 ( .VDD(
Vring ), .Y( INV_8_P ), .VSS( VSS ), .A( INV_8_N ) );
PLL_VCO_INV (*
integer library_binding = "ether";
 *)
INVC9 ( .VDD(
Vring ), .Y( INV_9_N ), .VSS( VSS ), .A( INV_9_P ) );

endmodule
