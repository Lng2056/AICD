// Verilog-AMS netlist generated by the AMS netlister, version ICOA5.2.51.500.7.
// Cadence Design Systems, Inc.

`include "disciplines.vams"

module adc_interp_array ( dm0n,dm0p,dm8n,dm8p,out0n,out0p,out1n,out1p,
out2n,out2p,out3n,out3p,out4n,out4p,out5n,out5p,out6n,out6p,out7n,
out7p,out8n,out8p,SIDDQ,VDD,VSS,bias100,ref0,ref1,ref10,ref2,ref3,ref4,
ref5,ref6,ref7,ref8,ref9,vinm,vinp );

output   dm0n;
output   dm0p;
output   dm8n;
output   dm8p;
output
 out0n;
output   out0p;
output   out1n;
output   out1p;
output
 out2n;
output   out2p;
output   out3n;
output   out3p;
output
 out4n;
output   out4p;
output   out5n;
output   out5p;
output
 out6n;
output   out6p;
output   out7n;
output   out7p;
output
 out8n;
output   out8p;
input   SIDDQ;
input   VDD;
input   VSS;

input   bias100;
input   ref0;
input   ref1;
input   ref10;
input
 ref2;
input   ref3;
input   ref4;
input   ref5;
input   ref6;
input
 ref7;
input   ref8;
input   ref9;
input   vinm;
input   vinp;

gpdk090_resnsppoly #(.w(8.4u), .r(100.029), .l(2.09u)) (*
integer
library_binding = "gpdk090";
 *)
R152 ( net111, net0131, VDD );
gpdk090_resnsppoly #(.w(8.4u), .r(100.029), .l(2.09u)) (*
integer
library_binding = "gpdk090";
 *)
R155 ( net0148, net0145, VDD );
gpdk090_resnsppoly #(.w(8.4u), .r(100.029), .l(2.09u)) (*
integer
library_binding = "gpdk090";
 *)
R164 ( net089, net051, VDD );
gpdk090_resnsppoly #(.w(8.4u), .r(100.029), .l(2.09u)) (*
integer
library_binding = "gpdk090";
 *)
R165 ( net0159, net089, VDD );
gpdk090_resnsppoly #(.w(8.4u), .r(100.029), .l(2.09u)) (*
integer
library_binding = "gpdk090";
 *)
R174 ( net110, net091, VDD );
gpdk090_resnsppoly #(.w(8.4u), .r(100.029), .l(2.09u)) (*
integer
library_binding = "gpdk090";
 *)
R158 ( net0133, net0136, VDD );
gpdk090_resnsppoly #(.w(8.4u), .r(100.029), .l(2.09u)) (*
integer
library_binding = "gpdk090";
 *)
R161 ( net0139, net0127, VDD );
gpdk090_resnsppoly #(.w(8.4u), .r(100.029), .l(2.09u)) (*
integer
library_binding = "gpdk090";
 *)
R163 ( net096, net0282, VDD );
gpdk090_resnsppoly #(.w(8.4u), .r(100.029), .l(2.09u)) (*
integer
library_binding = "gpdk090";
 *)
R154 ( net0131, net0148, VDD );
gpdk090_resnsppoly #(.w(8.4u), .r(100.029), .l(2.09u)) (*
integer
library_binding = "gpdk090";
 *)
R159 ( net0130, net0133, VDD );
gpdk090_resnsppoly #(.w(8.4u), .r(100.029), .l(2.09u)) (*
integer
library_binding = "gpdk090";
 *)
R157 ( net0136, net0139, VDD );
gpdk090_resnsppoly #(.w(8.4u), .r(100.029), .l(2.09u)) (*
integer
library_binding = "gpdk090";
 *)
R156 ( net0145, net0142, VDD );
gpdk090_resnsppoly #(.w(8.4u), .r(100.029), .l(2.09u)) (*
integer
library_binding = "gpdk090";
 *)
R160 ( net0142, net0130, VDD );
gpdk090_resnsppoly #(.w(8.4u), .r(100.029), .l(2.09u)) (*
integer
library_binding = "gpdk090";
 *)
R169 ( net090, net094, VDD );
gpdk090_resnsppoly #(.w(8.4u), .r(100.029), .l(2.09u)) (*
integer
library_binding = "gpdk090";
 *)
R173 ( net091, net0138, VDD );
gpdk090_resnsppoly #(.w(8.4u), .r(100.029), .l(2.09u)) (*
integer
library_binding = "gpdk090";
 *)
R167 ( net092, net095, VDD );
gpdk090_resnsppoly #(.w(8.4u), .r(100.029), .l(2.09u)) (*
integer
library_binding = "gpdk090";
 *)
R168 ( net095, net090, VDD );
gpdk090_resnsppoly #(.w(8.4u), .r(100.029), .l(2.09u)) (*
integer
library_binding = "gpdk090";
 *)
R166 ( net093, net0159, VDD );
gpdk090_resnsppoly #(.w(8.4u), .r(100.029), .l(2.09u)) (*
integer
library_binding = "gpdk090";
 *)
R162 ( net0127, net096, VDD );
gpdk090_resnsppoly #(.w(8.4u), .r(100.029), .l(2.09u)) (*
integer
library_binding = "gpdk090";
 *)
R0 ( out0n, dm0n, VDD );
gpdk090_resnsppoly #(.w(8.4u), .r(100.029), .l(2.09u)) (*
integer
library_binding = "gpdk090";
 *)
R34 ( out8p, dm8p, VDD );
gpdk090_resnsppoly #(.w(8.4u), .r(100.029), .l(2.09u)) (*
integer
library_binding = "gpdk090";
 *)
R35 ( out8n, dm8n, VDD );
gpdk090_resnsppoly #(.w(8.4u), .r(100.029), .l(2.09u)) (*
integer
library_binding = "gpdk090";
 *)
R36 ( dm8n, net0209, VDD );
gpdk090_resnsppoly #(.w(8.4u), .r(100.029), .l(2.09u)) (*
integer
library_binding = "gpdk090";
 *)
R37 ( dm8p, net0204, VDD );
gpdk090_resnsppoly #(.w(8.4u), .r(100.029), .l(2.09u)) (*
integer
library_binding = "gpdk090";
 *)
R38 ( net0204, net0217, VDD );
gpdk090_resnsppoly #(.w(8.4u), .r(100.029), .l(2.09u)) (*
integer
library_binding = "gpdk090";
 *)
R39 ( net0209, net0211, VDD );
gpdk090_resnsppoly #(.w(8.4u), .r(100.029), .l(2.09u)) (*
integer
library_binding = "gpdk090";
 *)
R40 ( net0211, net0210, VDD );
gpdk090_resnsppoly #(.w(8.4u), .r(100.029), .l(2.09u)) (*
integer
library_binding = "gpdk090";
 *)
R1 ( out0p, dm0p, VDD );
gpdk090_resnsppoly #(.w(8.4u), .r(100.029), .l(2.09u)) (*
integer
library_binding = "gpdk090";
 *)
R2 ( dm0p, net0223, VDD );
gpdk090_resnsppoly #(.w(8.4u), .r(100.029), .l(2.09u)) (*
integer
library_binding = "gpdk090";
 *)
R41 ( net0217, net0233, VDD );
gpdk090_resnsppoly #(.w(8.4u), .r(100.029), .l(2.09u)) (*
integer
library_binding = "gpdk090";
 *)
R3 ( dm0n, net0221, VDD );
gpdk090_resnsppoly #(.w(8.4u), .r(100.029), .l(2.09u)) (*
integer
library_binding = "gpdk090";
 *)
R4 ( net0221, net0220, VDD );
gpdk090_resnsppoly #(.w(8.4u), .r(100.029), .l(2.09u)) (*
integer
library_binding = "gpdk090";
 *)
R5 ( net0223, net0225, VDD );
gpdk090_resnsppoly #(.w(8.4u), .r(100.029), .l(2.09u)) (*
integer
library_binding = "gpdk090";
 *)
R6 ( net0225, net0224, VDD );
gpdk090_resnsppoly #(.w(8.4u), .r(100.029), .l(2.09u)) (*
integer
library_binding = "gpdk090";
 *)
R7 ( net0220, net0226, VDD );
gpdk090_resnsppoly #(.w(8.4u), .r(100.029), .l(2.09u)) (*
integer
library_binding = "gpdk090";
 *)
R8 ( net0226, net0241, VDD );
gpdk090_resnsppoly #(.w(8.4u), .r(100.029), .l(2.09u)) (*
integer
library_binding = "gpdk090";
 *)
R9 ( net0224, net0230, VDD );
gpdk090_resnsppoly #(.w(8.4u), .r(100.029), .l(2.09u)) (*
integer
library_binding = "gpdk090";
 *)
R42 ( net0233, net0232, VDD );
gpdk090_resnsppoly #(.w(8.4u), .r(100.029), .l(2.09u)) (*
integer
library_binding = "gpdk090";
 *)
R43 ( net0210, net0237, VDD );
gpdk090_resnsppoly #(.w(8.4u), .r(100.029), .l(2.09u)) (*
integer
library_binding = "gpdk090";
 *)
R44 ( net0237, net0236, VDD );
gpdk090_resnsppoly #(.w(8.4u), .r(100.029), .l(2.09u)) (*
integer
library_binding = "gpdk090";
 *)
R10 ( net0230, net0245, VDD );
gpdk090_resnsppoly #(.w(8.4u), .r(100.029), .l(2.09u)) (*
integer
library_binding = "gpdk090";
 *)
R11 ( net0241, net0243, VDD );
gpdk090_resnsppoly #(.w(8.4u), .r(100.029), .l(2.09u)) (*
integer
library_binding = "gpdk090";
 *)
R12 ( net0243, net0242, VDD );
gpdk090_resnsppoly #(.w(8.4u), .r(100.029), .l(2.09u)) (*
integer
library_binding = "gpdk090";
 *)
R13 ( net0245, net0247, VDD );
gpdk090_resnsppoly #(.w(8.4u), .r(100.029), .l(2.09u)) (*
integer
library_binding = "gpdk090";
 *)
R14 ( net0247, net110, VDD );
gpdk090_resnsppoly #(.w(8.4u), .r(100.029), .l(2.09u)) (*
integer
library_binding = "gpdk090";
 *)
R15 ( net0242, net111, VDD );
gpdk090_resnsppoly #(.w(8.4u), .r(100.029), .l(2.09u)) (*
integer
library_binding = "gpdk090";
 *)
R45 ( net0232, net0250, VDD );
gpdk090_resnsppoly #(.w(8.4u), .r(100.029), .l(2.09u)) (*
integer
library_binding = "gpdk090";
 *)
R46 ( net0250, net0252, VDD );
gpdk090_resnsppoly #(.w(8.4u), .r(100.029), .l(2.09u)) (*
integer
library_binding = "gpdk090";
 *)
R47 ( net0236, net0257, VDD );
gpdk090_resnsppoly #(.w(8.4u), .r(100.029), .l(2.09u)) (*
integer
library_binding = "gpdk090";
 *)
R48 ( net0257, net051, VDD );
gpdk090_resnsppoly #(.w(8.4u), .r(100.029), .l(2.09u)) (*
integer
library_binding = "gpdk090";
 *)
R49 ( net0252, net0282, VDD );
gpdk090_resnsppoly #(.w(8.4u), .r(100.029), .l(2.09u)) (*
integer
library_binding = "gpdk090";
 *)
R171 ( net0141, net092, VDD );
gpdk090_resnsppoly #(.w(8.4u), .r(100.029), .l(2.09u)) (*
integer
library_binding = "gpdk090";
 *)
R170 ( net094, net093, VDD );
gpdk090_resnsppoly #(.w(8.4u), .r(100.029), .l(2.09u)) (*
integer
library_binding = "gpdk090";
 *)
R172 ( net0138, net0141, VDD );

gpdk090_nmos2v #(.ps(41.2u), .m(44 * 2), .as(12p), .l(2u), .pd(20.6u),
 .ad(6p), .w(20u)) (*
integer library_binding = "gpdk090";
integer
passed_mfactor = "m";
 *)
NM5 ( VSS, VDD, VSS, VSS );
gpdk090_nmos2v #(.ps(41.2u), .m(43 * 2), .as(12p), .l(2u), .pd(20.6u),
 .ad(6p), .w(20u)) (*
integer library_binding = "gpdk090";
integer
passed_mfactor = "m";
 *)
NM7 ( VSS, bias100, VSS, VSS );
gpdk090_nmos2v #(.ps(41.2u), .m(1 * 2), .as(12p), .l(2u), .pd(20.6u),
.ad(6p), .w(20u)) (*
integer library_binding = "gpdk090";
integer
passed_mfactor = "m";
 *)
NM6 ( bias100, bias100, VSS, VSS );
gpdk090_nmos2v #(.ps(3.6u), .m(1 * 1), .as(720f), .l(280.0n), .pd(3.6u),
 .ad(720f), .w(1.2u)) (*
integer library_binding = "gpdk090";
integer
passed_mfactor = "m";
 *)
NM2 ( bias100, SIDDQ, VSS, VSS );

adc_interpolator (*
integer library_binding = "ether";
 *)
I11 ( .bias(
bias100 ), .inp( vinp ), .outp( net0282 ), .VDD( VDD ), .refn( ref0 ),
.inn( vinm ), .refp( ref10 ), .outn( net051 ), .VSS( VSS ) );
adc_interpolator (*
integer library_binding = "ether";
 *)
I10 ( .bias(
bias100 ), .inp( vinp ), .outp( out8p ), .VDD( VDD ), .refn( ref1 ), .inn(
vinm ), .refp( ref9 ), .outn( out8n ), .VSS( VSS ) );
adc_interpolator (*
integer library_binding = "ether";
 *)
I9 ( .bias(
bias100 ), .inp( vinp ), .outp( out0p ), .VDD( VDD ), .refn( ref9 ), .inn(
vinm ), .refp( ref1 ), .outn( out0n ), .VSS( VSS ) );
adc_interpolator (*
integer library_binding = "ether";
 *)
I8 ( .bias(
bias100 ), .inp( vinp ), .outp( out7p ), .VDD( VDD ), .refn( ref2 ), .inn(
vinm ), .refp( ref8 ), .outn( out7n ), .VSS( VSS ) );
adc_interpolator (*
integer library_binding = "ether";
 *)
I7 ( .bias(
bias100 ), .inp( vinp ), .outp( out6p ), .VDD( VDD ), .refn( ref3 ), .inn(
vinm ), .refp( ref7 ), .outn( out6n ), .VSS( VSS ) );
adc_interpolator (*
integer library_binding = "ether";
 *)
I6 ( .bias(
bias100 ), .inp( vinp ), .outp( out5p ), .VDD( VDD ), .refn( ref4 ), .inn(
vinm ), .refp( ref6 ), .outn( out5n ), .VSS( VSS ) );
adc_interpolator (*
integer library_binding = "ether";
 *)
I5 ( .bias(
bias100 ), .inp( vinp ), .outp( net110 ), .VDD( VDD ), .refn( ref10 ),
.inn( vinm ), .refp( ref0 ), .outn( net111 ), .VSS( VSS ) );
adc_interpolator (*
integer library_binding = "ether";
 *)
I4 ( .bias(
bias100 ), .inp( vinp ), .outp( out1p ), .VDD( VDD ), .refn( ref8 ), .inn(
vinm ), .refp( ref2 ), .outn( out1n ), .VSS( VSS ) );
adc_interpolator (*
integer library_binding = "ether";
 *)
I3 ( .bias(
bias100 ), .inp( vinp ), .outp( out2p ), .VDD( VDD ), .refn( ref7 ), .inn(
vinm ), .refp( ref3 ), .outn( out2n ), .VSS( VSS ) );
adc_interpolator (*
integer library_binding = "ether";
 *)
I2 ( .bias(
bias100 ), .inp( vinp ), .outp( out3p ), .VDD( VDD ), .refn( ref6 ), .inn(
vinm ), .refp( ref4 ), .outn( out3n ), .VSS( VSS ) );
adc_interpolator (*
integer library_binding = "ether";
 *)
I1 ( .bias(
bias100 ), .inp( vinp ), .outp( out4p ), .VDD( VDD ), .refn( ref5 ), .inn(
vinm ), .refp( ref5 ), .outn( out4n ), .VSS( VSS ) );

endmodule
