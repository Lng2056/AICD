// Verilog-AMS netlist generated by the AMS netlister, version ICOA5.2.51.500.7.
// Cadence Design Systems, Inc.

`include "disciplines.vams"

module nand3_2x_hv ( C,Y,B,A );

input   C;
output   Y;
input   B;
input   A;

wire (*
integer inh_conn_prop_name = "DVDD";
integer
inh_conn_def_value = "cds_globals.\\VDD! ";
 *)
\VDD! ;
wire (*
integer inh_conn_prop_name = "DVSS";
integer
inh_conn_def_value = "cds_globals.\\VSS! ";
 *)
\VSS! ;

gpdk090_pmos2v #(.ps(4u), .m(1 * 1), .as(840f), .l(280.0n), .pd(4u), .ad(840f),
 .w(1.4u)) (*
integer library_binding = "gpdk090";
integer
passed_mfactor = "m";
 *)
PM2 ( Y, C, \VDD! , \VDD!  );
gpdk090_pmos2v #(.ps(4u), .m(1 * 1), .as(840f), .l(280.0n), .pd(4u), .ad(840f),
 .w(1.4u)) (*
integer library_binding = "gpdk090";
integer
passed_mfactor = "m";
 *)
PM1 ( Y, A, \VDD! , \VDD!  );
gpdk090_pmos2v #(.ps(4u), .m(1 * 1), .as(840f), .l(280.0n), .pd(4u), .ad(840f),
 .w(1.4u)) (*
integer library_binding = "gpdk090";
integer
passed_mfactor = "m";
 *)
PM0 ( Y, B, \VDD! , \VDD!  );

gpdk090_nmos2v #(.ps(5.68u), .m(1 * 1), .as(1.344p), .l(280.0n), .pd(5.68u),
 .ad(1.344p), .w(2.24u)) (*
integer library_binding = "gpdk090";

integer passed_mfactor = "m";
 *)
NM0 ( net28, B, net037, \VSS!  );
gpdk090_nmos2v #(.ps(5.68u), .m(1 * 1), .as(1.344p), .l(280.0n), .pd(5.68u),
 .ad(1.344p), .w(2.24u)) (*
integer library_binding = "gpdk090";

integer passed_mfactor = "m";
 *)
NM2 ( net037, C, \VSS! , \VSS!  );
gpdk090_nmos2v #(.ps(5.68u), .m(1 * 1), .as(1.344p), .l(280.0n), .pd(5.68u),
 .ad(1.344p), .w(2.24u)) (*
integer library_binding = "gpdk090";

integer passed_mfactor = "m";
 *)
NM1 ( Y, A, net28, \VSS!  );

endmodule
