// Verilog-AMS netlist generated by the AMS netlister, version ICOA5.2.51.500.7.
// Cadence Design Systems, Inc.

`include "disciplines.vams"

module xor2_1x_hv ( Y,B,A );

output   Y;
input   B;
input   A;

wire (*
integer inh_conn_prop_name = "DVDD";
integer
inh_conn_def_value = "cds_globals.\\VDD! ";
 *)
\VDD! ;
wire (*
integer inh_conn_prop_name = "DVSS";
integer
inh_conn_def_value = "cds_globals.\\VSS! ";
 *)
\VSS! ;

gpdk090_pmos2v #(.ps(6.8u), .m(1 * 1), .as(1.68p), .l(280.0n), .pd(6.8u),
 .ad(1.68p), .w(2.8u)) (*
integer library_binding = "gpdk090";

integer passed_mfactor = "m";
 *)
PM5 ( Ab, A, \VDD! , \VDD!  );
gpdk090_pmos2v #(.ps(6.8u), .m(1 * 1), .as(1.68p), .l(280.0n), .pd(6.8u),
 .ad(1.68p), .w(2.8u)) (*
integer library_binding = "gpdk090";

integer passed_mfactor = "m";
 *)
PM4 ( Bb, B, \VDD! , \VDD!  );
gpdk090_pmos2v #(.ps(6.8u), .m(1 * 1), .as(1.68p), .l(280.0n), .pd(6.8u),
 .ad(1.68p), .w(2.8u)) (*
integer library_binding = "gpdk090";

integer passed_mfactor = "m";
 *)
PM2 ( net028, Bb, \VDD! , \VDD!  );
gpdk090_pmos2v #(.ps(6.8u), .m(1 * 1), .as(1.68p), .l(280.0n), .pd(6.8u),
 .ad(1.68p), .w(2.8u)) (*
integer library_binding = "gpdk090";

integer passed_mfactor = "m";
 *)
PM3 ( Y, A, net028, \VDD!  );
gpdk090_pmos2v #(.ps(6.8u), .m(1 * 1), .as(1.68p), .l(280.0n), .pd(6.8u),
 .ad(1.68p), .w(2.8u)) (*
integer library_binding = "gpdk090";

integer passed_mfactor = "m";
 *)
PM1 ( net044, B, \VDD! , \VDD!  );
gpdk090_pmos2v #(.ps(6.8u), .m(1 * 1), .as(1.68p), .l(280.0n), .pd(6.8u),
 .ad(1.68p), .w(2.8u)) (*
integer library_binding = "gpdk090";

integer passed_mfactor = "m";
 *)
PM0 ( Y, Ab, net044, \VDD!  );

gpdk090_nmos2v #(.ps(3.44u), .m(1 * 1), .as(672f), .l(280.0n), .pd(3.44u),
 .ad(672f), .w(1.12u)) (*
integer library_binding = "gpdk090";

integer passed_mfactor = "m";
 *)
NM0 ( net28, B, \VSS! , \VSS!  );
gpdk090_nmos2v #(.ps(3.44u), .m(1 * 1), .as(672f), .l(280.0n), .pd(3.44u),
 .ad(672f), .w(1.12u)) (*
integer library_binding = "gpdk090";

integer passed_mfactor = "m";
 *)
NM4 ( Bb, B, \VSS! , \VSS!  );
gpdk090_nmos2v #(.ps(3.44u), .m(1 * 1), .as(672f), .l(280.0n), .pd(3.44u),
 .ad(672f), .w(1.12u)) (*
integer library_binding = "gpdk090";

integer passed_mfactor = "m";
 *)
NM5 ( Ab, A, \VSS! , \VSS!  );
gpdk090_nmos2v #(.ps(3.44u), .m(1 * 1), .as(672f), .l(280.0n), .pd(3.44u),
 .ad(672f), .w(1.12u)) (*
integer library_binding = "gpdk090";

integer passed_mfactor = "m";
 *)
NM3 ( net045, Bb, \VSS! , \VSS!  );
gpdk090_nmos2v #(.ps(3.44u), .m(1 * 1), .as(672f), .l(280.0n), .pd(3.44u),
 .ad(672f), .w(1.12u)) (*
integer library_binding = "gpdk090";

integer passed_mfactor = "m";
 *)
NM2 ( Y, Ab, net045, \VSS!  );
gpdk090_nmos2v #(.ps(3.44u), .m(1 * 1), .as(672f), .l(280.0n), .pd(3.44u),
 .ad(672f), .w(1.12u)) (*
integer library_binding = "gpdk090";

integer passed_mfactor = "m";
 *)
NM1 ( Y, A, net28, \VSS!  );

endmodule
