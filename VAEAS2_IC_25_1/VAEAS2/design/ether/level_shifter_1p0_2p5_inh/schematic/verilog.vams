// Verilog-AMS netlist generated by the AMS netlister, version ICOA5.2.51.500.7.
// Cadence Design Systems, Inc.

`include "disciplines.vams"

module level_shifter_1p0_2p5_inh ( IN,.VDD_1p0(\VDD_1p0! ),.VDD_2p5(
\VDD_2p5! ),OUT,.VSS(\VSS! ) );

input   IN;
input  (*
integer inh_conn_prop_name = "VDD_1p0";

integer inh_conn_def_value = "cds_globals.\\VDD_1p0! ";
 *)

 \VDD_1p0! ;
input  (*
integer inh_conn_prop_name = "VDD_2p5";

integer inh_conn_def_value = "cds_globals.\\VDD_2p5! ";
 *)

 \VDD_2p5! ;
output   OUT;
input  (*
integer inh_conn_prop_name
 = "VSS";
integer inh_conn_def_value = "cds_globals.\\VSS! ";
 *)

 \VSS! ;

parameter td=0;
parameter trf=1E-10;

gpdk090_pmos1v #(.ps(5.19u), .m(1 * 1), .as(1.197p), .l(180.0n), .pd(5.19u),
 .ad(1.197p), .w(1.995u)) (*
integer library_binding = "gpdk090";

integer passed_mfactor = "m";
 *)
PM1 ( net87, IN, \VDD_1p0! ,
\VDD_1p0!  );

gpdk090_nmos1v #(.ps(2.53u), .m(1 * 1), .as(399f), .l(180.0n), .pd(2.53u),
 .ad(399f), .w(665n)) (*
integer library_binding = "gpdk090";
integer
passed_mfactor = "m";
 *)
NM0 ( net87, IN, \VSS! , \VSS!  );

gpdk090_pmos2v #(.ps(2.025u), .m(1 * 4), .as(337.5f), .l(280.0n), .pd(1.35u),
 .ad(225f), .w(750n)) (*
integer library_binding = "gpdk090";
integer
passed_mfactor = "m";
 *)
PM23 ( OUT, net118, \VDD_2p5! , \VDD_2p5!  );
gpdk090_pmos2v #(.ps(2.7u), .m(1 * 2), .as(450f), .l(280.0n), .pd(1.35u),
 .ad(225f), .w(750n)) (*
integer library_binding = "gpdk090";
integer
passed_mfactor = "m";
 *)
PM15 ( net122, out_b, \VDD_2p5! , \VDD_2p5!  );
gpdk090_pmos2v #(.ps(2.025u), .m(1 * 4), .as(337.5f), .l(280.0n), .pd(1.35u),
 .ad(225f), .w(750n)) (*
integer library_binding = "gpdk090";
integer
passed_mfactor = "m";
 *)
PM26 ( net118, out_b, \VDD_2p5! , \VDD_2p5!  );
gpdk090_pmos2v #(.ps(2.7u), .m(1 * 2), .as(450f), .l(280.0n), .pd(1.35u),
 .ad(225f), .w(750n)) (*
integer library_binding = "gpdk090";
integer
passed_mfactor = "m";
 *)
PM14 ( out_b, net122, \VDD_2p5! , \VDD_2p5!  );

gpdk090_nmos2v #(.ps(3.2u), .m(1 * 1), .as(600f), .l(280.0n), .pd(3.2u),
 .ad(600f), .w(1u)) (*
integer library_binding = "gpdk090";
integer
passed_mfactor = "m";
 *)
NM16 ( OUT, net118, \VSS! , \VSS!  );
gpdk090_nmos2v #(.ps(2.13333u), .m(1 * 6), .as(400f), .l(280.0n), .pd(1.6u),
 .ad(300f), .w(1u)) (*
integer library_binding = "gpdk090";
integer
passed_mfactor = "m";
 *)
NM2 ( out_b, net87, \VSS! , \VSS!  );
gpdk090_nmos2v #(.ps(3.2u), .m(1 * 1), .as(600f), .l(280.0n), .pd(3.2u),
 .ad(600f), .w(1u)) (*
integer library_binding = "gpdk090";
integer
passed_mfactor = "m";
 *)
NM17 ( net118, out_b, \VSS! , \VSS!  );
gpdk090_nmos2v #(.ps(2.13333u), .m(1 * 6), .as(400f), .l(280.0n), .pd(1.6u),
 .ad(300f), .w(1u)) (*
integer library_binding = "gpdk090";
integer
passed_mfactor = "m";
 *)
NM1 ( net122, IN, \VSS! , \VSS!  );

endmodule
