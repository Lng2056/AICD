// Verilog-AMS netlist generated by the AMS netlister, version ICOA5.2.51.500.7.
// Cadence Design Systems, Inc.

`include "disciplines.vams"

module clkbuf_8x_hv ( Y,A );

output   Y;
input   A;

wire (*
integer inh_conn_prop_name = "DVDD";
integer
inh_conn_def_value = "cds_globals.\\VDD! ";
 *)
\VDD! ;
wire (*
integer inh_conn_prop_name = "DVSS";
integer
inh_conn_def_value = "cds_globals.\\VSS! ";
 *)
\VSS! ;

gpdk090_pmos2v #(.ps(5.1u), .m(1 * 4), .as(1.26p), .l(280.0n), .pd(3.4u),
 .ad(840f), .w(2.8u)) (*
integer library_binding = "gpdk090";
integer
passed_mfactor = "m";
 *)
PM2 ( Y, net30, \VDD! , \VDD!  );
gpdk090_pmos2v #(.ps(6.8u), .m(1 * 2), .as(1.68p), .l(280.0n), .pd(3.4u),
 .ad(840f), .w(2.8u)) (*
integer library_binding = "gpdk090";
integer
passed_mfactor = "m";
 *)
PM3 ( net30, A, \VDD! , \VDD!  );

gpdk090_nmos2v #(.ps(2.58u), .m(1 * 4), .as(504f), .l(280.0n), .pd(1.72u),
 .ad(336f), .w(1.12u)) (*
integer library_binding = "gpdk090";

integer passed_mfactor = "m";
 *)
NM2 ( Y, net30, \VSS! , \VSS!  );
gpdk090_nmos2v #(.ps(3.44u), .m(1 * 2), .as(672f), .l(280.0n), .pd(1.72u),
 .ad(336f), .w(1.12u)) (*
integer library_binding = "gpdk090";

integer passed_mfactor = "m";
 *)
NM3 ( net30, A, \VSS! , \VSS!  );

endmodule
