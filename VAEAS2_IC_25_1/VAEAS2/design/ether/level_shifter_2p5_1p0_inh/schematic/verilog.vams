// Verilog-AMS netlist generated by the AMS netlister, version ICOA5.2.51.500.7.
// Cadence Design Systems, Inc.

`include "disciplines.vams"

module level_shifter_2p5_1p0_inh ( IN,.VDD_1p0(\VDD_1p0! ),.VDD_2p5(
\VDD_2p5! ),OUT,.VSS(\VSS! ) );

input   IN;
input  (*
integer inh_conn_prop_name = "VDD_1p0";

integer inh_conn_def_value = "cds_globals.\\VDD_1p0! ";
 *)

 \VDD_1p0! ;
input  (*
integer inh_conn_prop_name = "VDD_2p5";

integer inh_conn_def_value = "cds_globals.\\VDD_2p5! ";
 *)

 \VDD_2p5! ;
output   OUT;
input  (*
integer inh_conn_prop_name
 = "VSS";
integer inh_conn_def_value = "cds_globals.\\VSS! ";
 *)

 \VSS! ;

parameter td=0;
parameter trf=1E-10;

gpdk090_nmos2v #(.ps(2.13333u), .m(1 * 6), .as(400f), .l(280.0n), .pd(1.6u),
 .ad(300f), .w(1u)) (*
integer library_binding = "gpdk090";
integer
passed_mfactor = "m";
 *)
NM33 ( out_b, IN, \VSS! , \VSS!  );
gpdk090_nmos2v #(.ps(2.13333u), .m(1 * 6), .as(400f), .l(280.0n), .pd(1.6u),
 .ad(300f), .w(1u)) (*
integer library_binding = "gpdk090";
integer
passed_mfactor = "m";
 *)
NM34 ( net048, net059, \VSS! , \VSS!  );
gpdk090_nmos2v #(.ps(3.2u), .m(1 * 1), .as(600f), .l(280.0n), .pd(3.2u),
 .ad(600f), .w(1u)) (*
integer library_binding = "gpdk090";
integer
passed_mfactor = "m";
 *)
NM0 ( net059, IN, \VSS! , \VSS!  );

gpdk090_pmos2v #(.ps(2.025u), .m(1 * 4), .as(337.5f), .l(280.0n), .pd(1.35u),
 .ad(225f), .w(750n)) (*
integer library_binding = "gpdk090";
integer
passed_mfactor = "m";
 *)
PM0 ( net059, IN, \VDD_2p5! , \VDD_2p5!  );

gpdk090_pmos1v #(.ps(2.46u), .m(1 * 4), .as(468f), .l(180.0n), .pd(1.64u),
 .ad(312f), .w(1.04u)) (*
integer library_binding = "gpdk090";

integer passed_mfactor = "m";
 *)
PM3 ( OUT, out_b, \VDD_1p0! ,
\VDD_1p0!  );
gpdk090_pmos1v #(.ps(3.28u), .m(1 * 2), .as(624f), .l(180.0n), .pd(1.64u),
 .ad(312f), .w(1.04u)) (*
integer library_binding = "gpdk090";

integer passed_mfactor = "m";
 *)
PM24 ( net048, out_b, \VDD_1p0! ,
\VDD_1p0!  );
gpdk090_pmos1v #(.ps(3.28u), .m(1 * 2), .as(624f), .l(180.0n), .pd(1.64u),
 .ad(312f), .w(1.04u)) (*
integer library_binding = "gpdk090";

integer passed_mfactor = "m";
 *)
PM25 ( out_b, net048, \VDD_1p0! ,
\VDD_1p0!  );

gpdk090_nmos1v #(.ps(3.97u), .m(1 * 1), .as(831f), .l(180.0n), .pd(3.97u),
 .ad(831f), .w(1.385u)) (*
integer library_binding = "gpdk090";

integer passed_mfactor = "m";
 *)
NM1 ( OUT, out_b, \VSS! , \VSS!  );

endmodule
