// Verilog-AMS netlist generated by the AMS netlister, version ICOA5.2.51.500.7.
// Cadence Design Systems, Inc.

`include "disciplines.vams"

module PLL_CP ( IPLY_25u,CP_ITEST_25u,VDD,UP,PD,OUT,VSS,DN );

input   IPLY_25u;
output   CP_ITEST_25u;
input   VDD;
input   UP;

input   PD;
output   OUT;
input   VSS;
input   DN;

parameter RoutN=500000;
parameter RoutP=600000;
parameter tailCurrent=3E-05;
parameter delayToOutput=1E-10;
parameter ttol=0;

gpdk090_nmos2v #(.ps(1.6u), .m(1 * 2), .as(300f), .l(280n), .pd(360n),
 .ad(180f), .w(1u)) (*
integer library_binding = "gpdk090";
integer
passed_mfactor = "m";
 *)
NM24 ( OUT, SLEEP, VSS, VSS );
gpdk090_nmos2v #(.ps(3.2u), .m(1 * 1), .as(600f), .l(280.0n), .pd(3.2u),
 .ad(600f), .w(1u)) (*
integer library_binding = "gpdk090";
integer
passed_mfactor = "m";
 *)
NM25 ( net0161, SLEEP, VSS, VSS );
gpdk090_nmos2v #(.ps(13.2u), .m(1 * 1), .as(3.6p), .l(280.0n), .pd(13.2u),
 .ad(3.6p), .w(6u)) (*
integer library_binding = "gpdk090";
integer
passed_mfactor = "m";
 *)
NM23 ( VDD, net058, net0132, VSS );
gpdk090_nmos2v #(.ps(13.2u), .m(1 * 1), .as(3.6p), .l(280.0n), .pd(13.2u),
 .ad(3.6p), .w(6u)) (*
integer library_binding = "gpdk090";
integer
passed_mfactor = "m";
 *)
NM22 ( OUT, net059, net0132, VSS );
gpdk090_nmos2v #(.ps(14.4u), .m(1 * 4), .as(4.05p), .l(2u), .pd(9.6u),
 .ad(2.7p), .w(9u)) (*
integer library_binding = "gpdk090";
integer
passed_mfactor = "m";
 *)
NM21 ( net0132, net0161, VSS, VSS );
gpdk090_nmos2v #(.ps(13.2u), .m(1 * 1), .as(3.6p), .l(280.0n), .pd(13.2u),
 .ad(3.6p), .w(6u)) (*
integer library_binding = "gpdk090";
integer
passed_mfactor = "m";
 *)
NM26 ( net0149, NREF, net0153, VSS );
gpdk090_nmos2v #(.ps(14.4u), .m(1 * 4), .as(4.05p), .l(2u), .pd(9.6u),
 .ad(2.7p), .w(9u)) (*
integer library_binding = "gpdk090";
integer
passed_mfactor = "m";
 *)
NM17 ( net0153, net0161, VSS, VSS );
gpdk090_nmos2v #(.ps(14.4u), .m(1 * 4), .as(4.05p), .l(2u), .pd(9.6u),
 .ad(2.7p), .w(9u)) (*
integer library_binding = "gpdk090";
integer
passed_mfactor = "m";
 *)
NM19 ( net0145, net0161, VSS, VSS );
gpdk090_nmos2v #(.ps(13.2u), .m(1 * 1), .as(3.6p), .l(280.0n), .pd(13.2u),
 .ad(3.6p), .w(6u)) (*
integer library_binding = "gpdk090";
integer
passed_mfactor = "m";
 *)
NM27 ( net069, NREF, net0145, VSS );
gpdk090_nmos2v #(.ps(14.4u), .m(1 * 4), .as(4.05p), .l(2u), .pd(9.6u),
 .ad(2.7p), .w(9u)) (*
integer library_binding = "gpdk090";
integer
passed_mfactor = "m";
 *)
NM15 ( net0157, net0161, VSS, VSS );
gpdk090_nmos2v #(.ps(13.2u), .m(1 * 1), .as(3.6p), .l(280.0n), .pd(13.2u),
 .ad(3.6p), .w(6u)) (*
integer library_binding = "gpdk090";
integer
passed_mfactor = "m";
 *)
NM16 ( net0161, NREF, net0157, VSS );

gpdk090_pmos2v #(.ps(3.2u), .m(1 * 1), .as(600f), .l(280.0n), .pd(3.2u),
 .ad(600f), .w(1u)) (*
integer library_binding = "gpdk090";
integer
passed_mfactor = "m";
 *)
PM32 ( net0149, SLEEPb, VDD, VDD );
gpdk090_pmos2v #(.ps(27.4667u), .m(1 * 6), .as(8p), .l(2u), .pd(20.6u),
 .ad(6p), .w(20u)) (*
integer library_binding = "gpdk090";
integer
passed_mfactor = "m";
 *)
PM33 ( net0232, net0149, VDD, VDD );
gpdk090_pmos2v #(.ps(13.2u), .m(1 * 1), .as(3.6p), .l(280.0n), .pd(13.2u),
 .ad(3.6p), .w(6u)) (*
integer library_binding = "gpdk090";
integer
passed_mfactor = "m";
 *)
PM30 ( VSS, net071, net0220, VDD );
gpdk090_pmos2v #(.ps(13.2u), .m(1 * 1), .as(3.6p), .l(280.0n), .pd(13.2u),
 .ad(3.6p), .w(6u)) (*
integer library_binding = "gpdk090";
integer
passed_mfactor = "m";
 *)
PM31 ( OUT, net072, net0220, VDD );
gpdk090_pmos2v #(.ps(13.2u), .m(1 * 1), .as(3.6p), .l(280.0n), .pd(13.2u),
 .ad(3.6p), .w(6u)) (*
integer library_binding = "gpdk090";
integer
passed_mfactor = "m";
 *)
PM34 ( CP_ITEST_25u, PREF, net0232, VDD );
gpdk090_pmos2v #(.ps(27.4667u), .m(1 * 6), .as(8p), .l(2u), .pd(20.6u),
 .ad(6p), .w(20u)) (*
integer library_binding = "gpdk090";
integer
passed_mfactor = "m";
 *)
PM29 ( net0220, net0149, VDD, VDD );
gpdk090_pmos2v #(.ps(13.2u), .m(1 * 1), .as(3.6p), .l(280.0n), .pd(13.2u),
 .ad(3.6p), .w(6u)) (*
integer library_binding = "gpdk090";
integer
passed_mfactor = "m";
 *)
PM25 ( net0149, PREF, net0236, VDD );
gpdk090_pmos2v #(.ps(27.4667u), .m(1 * 6), .as(8p), .l(2u), .pd(20.6u),
 .ad(6p), .w(20u)) (*
integer library_binding = "gpdk090";
integer
passed_mfactor = "m";
 *)
PM26 ( net0236, net0149, VDD, VDD );
gpdk090_pmos2v #(.ps(21.2u), .m(1 * 2), .as(6p), .l(1u), .pd(10.6u), .ad(3p),
 .w(10u)) (*
integer library_binding = "gpdk090";
integer
passed_mfactor = "m";
 *)
PM22 ( net0241, IPLY_25u, VDD, VDD );
gpdk090_pmos2v #(.ps(3.2u), .m(1 * 1), .as(600f), .l(280.0n), .pd(3.2u),
 .ad(600f), .w(1u)) (*
integer library_binding = "gpdk090";
integer
passed_mfactor = "m";
 *)
PM23 ( IPLY_25u, SLEEPb, VDD, VDD );
gpdk090_pmos2v #(.ps(21.2u), .m(1 * 2), .as(6p), .l(1u), .pd(10.6u), .ad(3p),
 .w(10u)) (*
integer library_binding = "gpdk090";
integer
passed_mfactor = "m";
 *)
PM24 ( IPLY_25u, IPLY_25u, VDD, VDD );
gpdk090_pmos2v #(.ps(21.2u), .m(1 * 2), .as(6p), .l(1u), .pd(10.6u), .ad(3p),
 .w(10u)) (*
integer library_binding = "gpdk090";
integer
passed_mfactor = "m";
 *)
PM14 ( net0161, IPLY_25u, VDD, VDD );

PLL_INV3X (*
integer library_binding = "ether";
 *)
I11 ( .VDD( VDD ),
.Y( SLEEP ), .VSS( VSS ), .A( SLEEPb ) );
PLL_INV3X (*
integer library_binding = "ether";
 *)
I7 ( .VDD( VDD ),
.Y( SLEEPb ), .VSS( VSS ), .A( PD ) );

PLL_NDVR (*
integer library_binding = "ether";
 *)
I5 ( .DNn( net058 ),
.VREF( NREF ), .IPLY_25u( net0241 ), .DNp( net059 ), .VDD( VDD ), .PD(
SLEEP ), .VSS( VSS ), .DN( DN ), .FB_IN( net0162 ), .FB_OUT( net0162 ) );

PLL_PDVR (*
integer library_binding = "ether";
 *)
I4 ( .VREF( PREF ),
.IPLY_25u( net069 ), .UPn( net072 ), .VDD( VDD ), .UP( UP ), .PD(
SLEEP ), .VSS( VSS ), .UPp( net071 ), .FB_IN( net0179 ), .FB_OUT(
net0179 ) );

endmodule
