// Verilog-AMS netlist generated by the AMS netlister, version ICOA5.2.51.500.7.
// Cadence Design Systems, Inc.

`include "disciplines.vams"

module trans_NOR_1X ( Vgnd,Y,B,Vpwr,A );

input   Vgnd;
output   Y;
input   B;
input   Vpwr;
input   A;

gpdk090_pmos2v #(.ps(4.93u), .m(1 * 1), .as(1.119p), .l(280.0n), .pd(4.93u),
 .ad(1.119p), .w(1.865u)) (*
integer library_binding = "gpdk090";

integer passed_mfactor = "m";
 *)
PM0 ( Vpwr, B, net15_g0, Vpwr );
gpdk090_pmos2v #(.ps(4.93u), .m(1 * 1), .as(1.119p), .l(280.0n), .pd(4.93u),
 .ad(1.119p), .w(1.865u)) (*
integer library_binding = "gpdk090";

integer passed_mfactor = "m";
 *)
PM1 ( net15_g0, A, Y, Vpwr );

gpdk090_nmos2v #(.ps(3.07u), .m(1 * 1), .as(561f), .l(280.0n), .pd(3.07u),
 .ad(561f), .w(935n)) (*
integer library_binding = "gpdk090";
integer
passed_mfactor = "m";
 *)
NM1 ( Y, B, Vgnd, Vgnd );
gpdk090_nmos2v #(.ps(3.07u), .m(1 * 1), .as(561f), .l(280.0n), .pd(3.07u),
 .ad(561f), .w(935n)) (*
integer library_binding = "gpdk090";
integer
passed_mfactor = "m";
 *)
NM0 ( Y, A, Vgnd, Vgnd );

endmodule
