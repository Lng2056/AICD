// Verilog-AMS netlist generated by the AMS netlister, version ICOA5.2.51.500.7.
// Cadence Design Systems, Inc.

`include "disciplines.vams"

module adc_64comparators ( out,SIDDQ,VDD,VSS,dm0n,dm0p,dm8n,dm8p,
ibiasA100,ibiasB100,ibiasC100,ibiasD100,ibiasE100,ibiasF100,ibiasG100,
ibiasH100,in0n,in0p,in1n,in1p,in2n,in2p,in3n,in3p,in4n,in4p,in5n,in5p,
in6n,in6p,in7n,in7p,in8n,in8p,ph1,ph2b );

output [62:0]  out;
input   SIDDQ;
input   VDD;
input   VSS;
input
 dm0n;
input   dm0p;
input   dm8n;
input   dm8p;
input   ibiasA100;

input   ibiasB100;
input   ibiasC100;
input   ibiasD100;
input
 ibiasE100;
input   ibiasF100;
input   ibiasG100;
input   ibiasH100;

input   in0n;
input   in0p;
input   in1n;
input   in1p;
input   in2n;

input   in2p;
input   in3n;
input   in3p;
input   in4n;
input   in4p;

input   in5n;
input   in5p;
input   in6n;
input   in6p;
input   in7n;

input   in7p;
input   in8n;
input   in8p;
input   ph1;
input   ph2b;

wire [63:0] out_netclash;

cds_alias #(.width(63)) (*
integer library_binding = "basic";
integer
view_binding = "functional";
 *)
ams_alias_inst_0 (out[62:0],
out_netclash[62:0]);

adc_comparator_actr (*
integer library_binding = "ether";
 *)
dummy0
 ( .SIDDQ( SIDDQ ), .inp( dm0p ), .outp( net148 ), .VDD( VDD ), .ph2b(
ph2b ), .inm( dm0n ), .ph1( ph1 ), .Vbias( ibiasA100 ), .VSS( VSS ) );
adc_comparator_actr (*
integer library_binding = "ether";
 *)
dummy1
 ( .SIDDQ( SIDDQ ), .inp( dm8p ), .outp( net147 ), .VDD( VDD ), .ph2b(
ph2b ), .inm( dm8n ), .ph1( ph1 ), .Vbias( ibiasH100 ), .VSS( VSS ) );

adc_comparator_array_actr (*
integer library_binding = "ether";
 *)
I8
 ( .In1n( in7n ), .SIDDQ( SIDDQ ), .In1p( in7p ), .in2p( in8p ), .VDD(
VDD ), .ph2b( ph2b ), .ph1( ph1 ), .out( out_netclash[63:56] ), .in2n(
in8n ), .ibias100( ibiasH100 ), .VSS( VSS ) );
adc_comparator_array_actr (*
integer library_binding = "ether";
 *)
I7
 ( .In1n( in5n ), .SIDDQ( SIDDQ ), .In1p( in5p ), .in2p( in6p ), .VDD(
VDD ), .ph2b( ph2b ), .ph1( ph1 ), .out( out_netclash[47:40] ), .in2n(
in6n ), .ibias100( ibiasF100 ), .VSS( VSS ) );
adc_comparator_array_actr (*
integer library_binding = "ether";
 *)
I6
 ( .In1n( in3n ), .SIDDQ( SIDDQ ), .In1p( in3p ), .in2p( in4p ), .VDD(
VDD ), .ph2b( ph2b ), .ph1( ph1 ), .out( out_netclash[31:24] ), .in2n(
in4n ), .ibias100( ibiasD100 ), .VSS( VSS ) );
adc_comparator_array_actr (*
integer library_binding = "ether";
 *)
I5
 ( .In1n( in1n ), .SIDDQ( SIDDQ ), .In1p( in1p ), .in2p( in2p ), .VDD(
VDD ), .ph2b( ph2b ), .ph1( ph1 ), .out( out_netclash[15:8] ), .in2n(
in2n ), .ibias100( ibiasB100 ), .VSS( VSS ) );
adc_comparator_array_actr (*
integer library_binding = "ether";
 *)
I4
 ( .In1n( in6n ), .SIDDQ( SIDDQ ), .In1p( in6p ), .in2p( in7p ), .VDD(
VDD ), .ph2b( ph2b ), .ph1( ph1 ), .out( out_netclash[55:48] ), .in2n(
in7n ), .ibias100( ibiasG100 ), .VSS( VSS ) );
adc_comparator_array_actr (*
integer library_binding = "ether";
 *)
I3
 ( .In1n( in4n ), .SIDDQ( SIDDQ ), .In1p( in4p ), .in2p( in5p ), .VDD(
VDD ), .ph2b( ph2b ), .ph1( ph1 ), .out( out_netclash[39:32] ), .in2n(
in5n ), .ibias100( ibiasE100 ), .VSS( VSS ) );
adc_comparator_array_actr (*
integer library_binding = "ether";
 *)
I2
 ( .In1n( in2n ), .SIDDQ( SIDDQ ), .In1p( in2p ), .in2p( in3p ), .VDD(
VDD ), .ph2b( ph2b ), .ph1( ph1 ), .out( out_netclash[23:16] ), .in2n(
in3n ), .ibias100( ibiasC100 ), .VSS( VSS ) );
adc_comparator_array_actr (*
integer library_binding = "ether";
 *)
I1
 ( .In1n( in0n ), .SIDDQ( SIDDQ ), .In1p( in0p ), .in2p( in1p ), .VDD(
VDD ), .ph2b( ph2b ), .ph1( ph1 ), .out( out_netclash[7:0] ), .in2n(
in1n ), .ibias100( ibiasA100 ), .VSS( VSS ) );

endmodule
