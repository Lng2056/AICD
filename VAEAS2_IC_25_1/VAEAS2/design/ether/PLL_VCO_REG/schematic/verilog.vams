// Verilog-AMS netlist generated by the AMS netlister, version ICOA5.2.51.500.7.
// Cadence Design Systems, Inc.

`include "disciplines.vams"

module PLL_VCO_REG ( IEXT_100u,VFB,VDD,PD,VSS,Vcontrol,VRING );

input   IEXT_100u;
input   VFB;
input   VDD;
input   PD;
input
 VSS;
input   Vcontrol;
output   VRING;

gpdk090_pmos2v #(.ps(3.2u), .m(1 * 1), .as(600f), .l(280.0n), .pd(3.2u),
 .ad(600f), .w(1u)) (*
integer library_binding = "gpdk090";
integer
passed_mfactor = "m";
 *)
PM0 ( net78, PDb, VDD, VDD );
gpdk090_pmos2v #(.ps(17.6u), .m(1 * 1), .as(4.92p), .l(280.0n), .pd(17.6u),
 .ad(4.92p), .w(8.2u)) (*
integer library_binding = "gpdk090";

integer passed_mfactor = "m";
 *)
PM11 ( net78, net78, VDD, VDD );
gpdk090_pmos2v #(.ps(48.9u), .m(1 * 4), .as(14.4p), .l(280.0n), .pd(32.6u),
 .ad(9.6p), .w(32u)) (*
integer library_binding = "gpdk090";
integer
passed_mfactor = "m";
 *)
PM13 ( net49, net66, VDD, VDD );
gpdk090_pmos2v #(.ps(34.23u), .m(1 * 40), .as(10.08p), .l(280.0n), .pd(32.6u),
 .ad(9.6p), .w(32u)) (*
integer library_binding = "gpdk090";
integer
passed_mfactor = "m";
 *)
PM16 ( net37, net66, VDD, VDD );
gpdk090_pmos2v #(.ps(41.2u), .m(1 * 2), .as(12p), .l(400n), .pd(20.6u),
 .ad(6p), .w(20u)) (*
integer library_binding = "gpdk090";
integer
passed_mfactor = "m";
 *)
PM17 ( net54, IEXT_100u, VDD, VDD );
gpdk090_pmos2v #(.ps(3.2u), .m(1 * 1), .as(600f), .l(280.0n), .pd(3.2u),
 .ad(600f), .w(1u)) (*
integer library_binding = "gpdk090";
integer
passed_mfactor = "m";
 *)
PM9 ( IEXT_100u, PDb, VDD, VDD );
gpdk090_pmos2v #(.ps(34.23u), .m(1 * 40), .as(10.08p), .l(280.0n), .pd(32.6u),
 .ad(9.6p), .w(32u)) (*
integer library_binding = "gpdk090";
integer
passed_mfactor = "m";
 *)
PM15 ( VFB, net78, net37, VDD );
gpdk090_pmos2v #(.ps(41.2u), .m(1 * 2), .as(12p), .l(400n), .pd(20.6u),
 .ad(6p), .w(20u)) (*
integer library_binding = "gpdk090";
integer
passed_mfactor = "m";
 *)
PM8 ( IEXT_100u, IEXT_100u, VDD, VDD );
gpdk090_pmos2v #(.ps(30.9u), .m(1 * 4), .as(9p), .l(400n), .pd(20.6u),
 .ad(6p), .w(20u)) (*
integer library_binding = "gpdk090";
integer
passed_mfactor = "m";
 *)
PM14 ( net94, IEXT_100u, VDD, VDD );
gpdk090_pmos2v #(.ps(48.9u), .m(1 * 4), .as(14.4p), .l(280.0n), .pd(32.6u),
 .ad(9.6p), .w(32u)) (*
integer library_binding = "gpdk090";
integer
passed_mfactor = "m";
 *)
PM12 ( net66, net78, net49, VDD );
gpdk090_pmos2v #(.ps(9.9u), .m(1 * 4), .as(2.7p), .l(280.0n), .pd(6.6u),
 .ad(1.8p), .w(6u)) (*
integer library_binding = "gpdk090";
integer
passed_mfactor = "m";
 *)
PM10 ( vNGATE, vPGATE, VFB, VFB );

gpdk090_nmos2v #(.ps(3.2u), .m(1 * 1), .as(600f), .l(280.0n), .pd(3.2u),
 .ad(600f), .w(1u)) (*
integer library_binding = "gpdk090";
integer
passed_mfactor = "m";
 *)
NM0 ( net94, PD, VSS, VSS );
gpdk090_nmos2v #(.ps(3.2u), .m(1 * 1), .as(600f), .l(280.0n), .pd(3.2u),
 .ad(600f), .w(1u)) (*
integer library_binding = "gpdk090";
integer
passed_mfactor = "m";
 *)
NM1 ( vNGATE, PD, VSS, VSS );
gpdk090_nmos2v #(.ps(21.2u), .m(1 * 1), .as(6p), .l(280.0n), .pd(21.2u),
 .ad(6p), .w(10u)) (*
integer library_binding = "gpdk090";
integer
passed_mfactor = "m";
 *)
NM2 ( VRING, PD, VSS, VSS );
gpdk090_nmos2v #(.ps(15.9u), .m(1 * 4), .as(4.5p), .l(400n), .pd(10.6u),
 .ad(3p), .w(10u)) (*
integer library_binding = "gpdk090";
integer
passed_mfactor = "m";
 *)
NM34 ( net54, net94, net90, VSS );
gpdk090_nmos2v #(.ps(15.9u), .m(1 * 4), .as(4.5p), .l(400n), .pd(10.6u),
 .ad(3p), .w(10u)) (*
integer library_binding = "gpdk090";
integer
passed_mfactor = "m";
 *)
NM40 ( vPGATE, net94, net62, VSS );
gpdk090_nmos2v #(.ps(15.9u), .m(1 * 4), .as(4.5p), .l(1u), .pd(10.6u),
 .ad(3p), .w(10u)) (*
integer library_binding = "gpdk090";
integer
passed_mfactor = "m";
 *)
NM39 ( net62, net54, VSS, VSS );
gpdk090_nmos2v #(.ps(11.925u), .m(1 * 16), .as(3.375p), .l(400n), .pd(10.6u),
 .ad(3p), .w(10u)) (*
integer library_binding = "gpdk090";
integer
passed_mfactor = "m";
 *)
NM37 ( net66, net94, net86, VSS );
gpdk090_nmos2v #(.ps(13.25u), .m(1 * 8), .as(3.75p), .l(1u), .pd(10.6u),
 .ad(3p), .w(10u)) (*
integer library_binding = "gpdk090";
integer
passed_mfactor = "m";
 *)
NM22 ( net70, net54, VSS, VSS );
gpdk090_nmos2v #(.ps(15.9u), .m(1 * 4), .as(4.5p), .l(1u), .pd(10.6u),
 .ad(3p), .w(10u)) (*
integer library_binding = "gpdk090";
integer
passed_mfactor = "m";
 *)
NM42 ( net74, net54, VSS, VSS );
gpdk090_nmos2v #(.ps(13.25u), .m(1 * 8), .as(3.75p), .l(400n), .pd(10.6u),
 .ad(3p), .w(10u)) (*
integer library_binding = "gpdk090";
integer
passed_mfactor = "m";
 *)
NM36 ( net78, net94, net70, VSS );
gpdk090_nmos2v #(.ps(15.9u), .m(1 * 4), .as(4.5p), .l(400n), .pd(10.6u),
 .ad(3p), .w(10u)) (*
integer library_binding = "gpdk090";
integer
passed_mfactor = "m";
 *)
NM41 ( vNGATE, net94, net74, VSS );
gpdk090_nmos2v #(.ps(11.925u), .m(1 * 16), .as(3.375p), .l(1u), .pd(10.6u),
 .ad(3p), .w(10u)) (*
integer library_binding = "gpdk090";
integer
passed_mfactor = "m";
 *)
NM38 ( net86, net54, VSS, VSS );
gpdk090_nmos2v #(.ps(15.9u), .m(1 * 4), .as(4.5p), .l(1u), .pd(10.6u),
 .ad(3p), .w(10u)) (*
integer library_binding = "gpdk090";
integer
passed_mfactor = "m";
 *)
NM35 ( net90, net54, VSS, VSS );
gpdk090_nmos2v #(.ps(13.2u), .m(1 * 1), .as(3.6p), .l(400n), .pd(13.2u),
 .ad(3.6p), .w(6u)) (*
integer library_binding = "gpdk090";
integer
passed_mfactor = "m";
 *)
NM33 ( net94, net94, VSS, VSS );
gpdk090_nmos2v #(.ps(22.3167u), .m(1 * 24), .as(6.5p), .l(280.0n), .pd(20.6u),
 .ad(6p), .w(20u)) (*
integer library_binding = "gpdk090";
integer
passed_mfactor = "m";
 *)
NM18 ( VRING, vNGATE, VSS, VSS );
gpdk090_nmos2v #(.ps(9.9u), .m(1 * 4), .as(2.7p), .l(280.0n), .pd(6.6u),
 .ad(1.8p), .w(6u)) (*
integer library_binding = "gpdk090";
integer
passed_mfactor = "m";
 *)
NM12 ( VFB, Vcontrol, vPGATE, VSS );

gpdk090_nmoscap2v #(.m(1 * 16), .l(4.8u), .w(21.485u)) (*
integer
library_binding = "gpdk090";
integer passed_mfactor = "m";
 *)
C0 (
VSS, VRING, VSS, VSS );

gpdk090_pmoscap2v #(.m(1 * 16), .l(5u), .w(8.105u)) (*
integer
library_binding = "gpdk090";
integer passed_mfactor = "m";
 *)
C1 (
vNGATE, VRING, vNGATE, vNGATE );

PLL_VCO_INV (*
integer library_binding = "ether";
 *)
I61 ( .VDD( VDD ),
.Y( PDb ), .VSS( VSS ), .A( PD ) );

endmodule
