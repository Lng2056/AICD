// Verilog-AMS netlist generated by the AMS netlister, version ICOA5.2.51.500.7.
// Cadence Design Systems, Inc.

`include "disciplines.vams"

module Bias_bdgp_trim ( SEL,VDD,B,A );

input [15:0]  SEL;
input   VDD;
input   B;
input   A;

gpdk090_resnsppoly #(.w(6u), .r(199.794), .l(2.985u)) (*
integer
library_binding = "gpdk090";
 *)
R1 ( net044, B, VDD );
gpdk090_resnsppoly #(.w(6u), .r(199.794), .l(2.985u)) (*
integer
library_binding = "gpdk090";
 *)
R10 ( net140, net143, VDD );
gpdk090_resnsppoly #(.w(6u), .r(199.794), .l(2.985u)) (*
integer
library_binding = "gpdk090";
 *)
R8 ( net146, net113, VDD );
gpdk090_resnsppoly #(.w(6u), .r(199.794), .l(2.985u)) (*
integer
library_binding = "gpdk090";
 *)
R7 ( net113, net116, VDD );
gpdk090_resnsppoly #(.w(6u), .r(199.794), .l(2.985u)) (*
integer
library_binding = "gpdk090";
 *)
R6 ( net116, net119, VDD );
gpdk090_resnsppoly #(.w(6u), .r(199.794), .l(2.985u)) (*
integer
library_binding = "gpdk090";
 *)
R2 ( net131, net044, VDD );
gpdk090_resnsppoly #(.w(6u), .r(199.794), .l(2.985u)) (*
integer
library_binding = "gpdk090";
 *)
R3 ( net134, net131, VDD );
gpdk090_resnsppoly #(.w(6u), .r(199.794), .l(2.985u)) (*
integer
library_binding = "gpdk090";
 *)
R4 ( net122, net134, VDD );
gpdk090_resnsppoly #(.w(6u), .r(199.794), .l(2.985u)) (*
integer
library_binding = "gpdk090";
 *)
R5 ( net119, net122, VDD );
gpdk090_resnsppoly #(.w(6u), .r(199.794), .l(2.985u)) (*
integer
library_binding = "gpdk090";
 *)
R13 ( net155, net149, VDD );
gpdk090_resnsppoly #(.w(6u), .r(199.794), .l(2.985u)) (*
integer
library_binding = "gpdk090";
 *)
R12 ( net149, net137, VDD );
gpdk090_resnsppoly #(.w(6u), .r(199.794), .l(2.985u)) (*
integer
library_binding = "gpdk090";
 *)
R11 ( net137, net140, VDD );
gpdk090_resnsppoly #(.w(6u), .r(199.794), .l(2.985u)) (*
integer
library_binding = "gpdk090";
 *)
R9 ( net143, net146, VDD );
gpdk090_resnsppoly #(.w(6u), .r(199.794), .l(2.985u)) (*
integer
library_binding = "gpdk090";
 *)
R14 ( net152, net155, VDD );
gpdk090_resnsppoly #(.w(6u), .r(199.794), .l(2.985u)) (*
integer
library_binding = "gpdk090";
 *)
R16 ( A, net158, VDD );
gpdk090_resnsppoly #(.w(6u), .r(199.794), .l(2.985u)) (*
integer
library_binding = "gpdk090";
 *)
R15 ( net158, net152, VDD );

gpdk090_pmos2v #(.ps(24.53u), .m(1 * 1), .as(6.999p), .l(280.0n), .pd(24.53u),
 .ad(6.999p), .w(11.665u)) (*
integer library_binding = "gpdk090";

integer passed_mfactor = "m";
 *)
PM6 ( net137, SEL[5], VDD, VDD );
gpdk090_pmos2v #(.ps(24.53u), .m(1 * 1), .as(6.999p), .l(280.0n), .pd(24.53u),
 .ad(6.999p), .w(11.665u)) (*
integer library_binding = "gpdk090";

integer passed_mfactor = "m";
 *)
PM16 ( net146, SEL[8], VDD, VDD );
gpdk090_pmos2v #(.ps(24.53u), .m(1 * 1), .as(6.999p), .l(280.0n), .pd(24.53u),
 .ad(6.999p), .w(11.665u)) (*
integer library_binding = "gpdk090";

integer passed_mfactor = "m";
 *)
PM15 ( net113, SEL[9], VDD, VDD );
gpdk090_pmos2v #(.ps(24.53u), .m(1 * 1), .as(6.999p), .l(280.0n), .pd(24.53u),
 .ad(6.999p), .w(11.665u)) (*
integer library_binding = "gpdk090";

integer passed_mfactor = "m";
 *)
PM14 ( net116, SEL[10], VDD, VDD );
gpdk090_pmos2v #(.ps(24.53u), .m(1 * 1), .as(6.999p), .l(280.0n), .pd(24.53u),
 .ad(6.999p), .w(11.665u)) (*
integer library_binding = "gpdk090";

integer passed_mfactor = "m";
 *)
PM13 ( net119, SEL[11], VDD, VDD );
gpdk090_pmos2v #(.ps(24.53u), .m(1 * 1), .as(6.999p), .l(280.0n), .pd(24.53u),
 .ad(6.999p), .w(11.665u)) (*
integer library_binding = "gpdk090";

integer passed_mfactor = "m";
 *)
PM12 ( net044, SEL[15], VDD, VDD );
gpdk090_pmos2v #(.ps(24.53u), .m(1 * 1), .as(6.999p), .l(280.0n), .pd(24.53u),
 .ad(6.999p), .w(11.665u)) (*
integer library_binding = "gpdk090";

integer passed_mfactor = "m";
 *)
PM11 ( net131, SEL[14], VDD, VDD );
gpdk090_pmos2v #(.ps(24.53u), .m(1 * 1), .as(6.999p), .l(280.0n), .pd(24.53u),
 .ad(6.999p), .w(11.665u)) (*
integer library_binding = "gpdk090";

integer passed_mfactor = "m";
 *)
PM10 ( net134, SEL[13], VDD, VDD );
gpdk090_pmos2v #(.ps(24.53u), .m(1 * 1), .as(6.999p), .l(280.0n), .pd(24.53u),
 .ad(6.999p), .w(11.665u)) (*
integer library_binding = "gpdk090";

integer passed_mfactor = "m";
 *)
PM9 ( net122, SEL[12], VDD, VDD );
gpdk090_pmos2v #(.ps(24.53u), .m(1 * 1), .as(6.999p), .l(280.0n), .pd(24.53u),
 .ad(6.999p), .w(11.665u)) (*
integer library_binding = "gpdk090";

integer passed_mfactor = "m";
 *)
PM8 ( net149, SEL[4], VDD, VDD );
gpdk090_pmos2v #(.ps(24.53u), .m(1 * 1), .as(6.999p), .l(280.0n), .pd(24.53u),
 .ad(6.999p), .w(11.665u)) (*
integer library_binding = "gpdk090";

integer passed_mfactor = "m";
 *)
PM5 ( net140, SEL[6], VDD, VDD );
gpdk090_pmos2v #(.ps(24.53u), .m(1 * 1), .as(6.999p), .l(280.0n), .pd(24.53u),
 .ad(6.999p), .w(11.665u)) (*
integer library_binding = "gpdk090";

integer passed_mfactor = "m";
 *)
PM4 ( net143, SEL[7], VDD, VDD );
gpdk090_pmos2v #(.ps(24.53u), .m(1 * 1), .as(6.999p), .l(280.0n), .pd(24.53u),
 .ad(6.999p), .w(11.665u)) (*
integer library_binding = "gpdk090";

integer passed_mfactor = "m";
 *)
PM7 ( A, SEL[0], VDD, VDD );
gpdk090_pmos2v #(.ps(24.53u), .m(1 * 1), .as(6.999p), .l(280.0n), .pd(24.53u),
 .ad(6.999p), .w(11.665u)) (*
integer library_binding = "gpdk090";

integer passed_mfactor = "m";
 *)
PM1 ( net158, SEL[1], VDD, VDD );
gpdk090_pmos2v #(.ps(24.53u), .m(1 * 1), .as(6.999p), .l(280.0n), .pd(24.53u),
 .ad(6.999p), .w(11.665u)) (*
integer library_binding = "gpdk090";

integer passed_mfactor = "m";
 *)
PM3 ( net155, SEL[3], VDD, VDD );
gpdk090_pmos2v #(.ps(24.53u), .m(1 * 1), .as(6.999p), .l(280.0n), .pd(24.53u),
 .ad(6.999p), .w(11.665u)) (*
integer library_binding = "gpdk090";

integer passed_mfactor = "m";
 *)
PM2 ( net152, SEL[2], VDD, VDD );

endmodule
