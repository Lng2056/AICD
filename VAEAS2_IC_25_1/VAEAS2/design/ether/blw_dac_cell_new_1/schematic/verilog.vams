// Verilog-AMS netlist generated by the AMS netlister, version ICOA5.2.51.500.7.
// Cadence Design Systems, Inc.

`include "disciplines.vams"

module blw_dac_cell_new_1 ( avdd,pos,up,neg,vbiasp,siddq,agnd,down );

input   avdd;
output   pos;
input   up;
output   neg;
input
 vbiasp;
input   siddq;
input   agnd;
input   down;

gpdk090_pmos2v #(.ps(3.53u), .m(1 * 1), .as(699f), .l(280.0n), .pd(3.53u),
 .ad(699f), .w(1.165u)) (*
integer library_binding = "gpdk090";

integer passed_mfactor = "m";
 *)
PM12 ( pos, xsiddq, avdd, avdd );
gpdk090_pmos2v #(.ps(3.53u), .m(1 * 1), .as(699f), .l(280.0n), .pd(3.53u),
 .ad(699f), .w(1.165u)) (*
integer library_binding = "gpdk090";

integer passed_mfactor = "m";
 *)
PM13 ( neg, xsiddq, avdd, avdd );
gpdk090_pmos2v #(.ps(11.2u), .m(1 * 2), .as(3p), .l(2.5u), .pd(5.6u),
.ad(1.5p), .w(5u)) (*
integer library_binding = "gpdk090";
integer
passed_mfactor = "m";
 *)
PM18 ( neg, vbiasp, avdd, avdd );
gpdk090_pmos2v #(.ps(11.2u), .m(1 * 2), .as(3p), .l(2.5u), .pd(5.6u),
.ad(1.5p), .w(5u)) (*
integer library_binding = "gpdk090";
integer
passed_mfactor = "m";
 *)
PM15 ( pos, vbiasp, avdd, avdd );
gpdk090_pmos2v #(.ps(11.2u), .m(1 * 2), .as(3p), .l(2.5u), .pd(5.6u),
.ad(1.5p), .w(5u)) (*
integer library_binding = "gpdk090";
integer
passed_mfactor = "m";
 *)
PM17 ( net277, vbiasp, avdd, avdd );
gpdk090_pmos2v #(.ps(11.2u), .m(1 * 2), .as(3p), .l(2.5u), .pd(5.6u),
.ad(1.5p), .w(5u)) (*
integer library_binding = "gpdk090";
integer
passed_mfactor = "m";
 *)
PM16 ( net265, vbiasp, avdd, avdd );
gpdk090_pmos2v #(.ps(3.53u), .m(1 * 1), .as(699f), .l(280.0n), .pd(3.53u),
 .ad(699f), .w(1.165u)) (*
integer library_binding = "gpdk090";

integer passed_mfactor = "m";
 *)
PM1 ( pos, up_delay, net277, avdd );
gpdk090_pmos2v #(.ps(3.53u), .m(1 * 1), .as(699f), .l(280.0n), .pd(3.53u),
 .ad(699f), .w(1.165u)) (*
integer library_binding = "gpdk090";

integer passed_mfactor = "m";
 *)
PM0 ( pos, xdown, net265, avdd );
gpdk090_pmos2v #(.ps(3.53u), .m(1 * 1), .as(699f), .l(280.0n), .pd(3.53u),
 .ad(699f), .w(1.165u)) (*
integer library_binding = "gpdk090";

integer passed_mfactor = "m";
 *)
PM5 ( neg, xup, net277, avdd );
gpdk090_pmos2v #(.ps(3.53u), .m(1 * 1), .as(699f), .l(280.0n), .pd(3.53u),
 .ad(699f), .w(1.165u)) (*
integer library_binding = "gpdk090";

integer passed_mfactor = "m";
 *)
PM4 ( neg, down_delay, net265, avdd );

and2_1x_hv (*
integer library_binding = "ether";
integer cds_net_set
[0:1] = { "DVDD","DVSS" };
integer DVDD = "avdd";
integer DVSS
 = "agnd";
 *)
I3 ( .Y( up_delay ), .B( xsiddq ), .A( net153 ) );
and2_1x_hv (*
integer library_binding = "ether";
integer cds_net_set
[0:1] = { "DVDD","DVSS" };
integer DVDD = "avdd";
integer DVSS
 = "agnd";
 *)
I7 ( .Y( down_delay ), .B( xsiddq ), .A( net148 ) );
and2_1x_hv (*
integer library_binding = "ether";
integer cds_net_set
[0:1] = { "DVDD","DVSS" };
integer DVDD = "avdd";
integer DVSS
 = "agnd";
 *)
I8 ( .Y( xdown ), .B( xsiddq ), .A( net147 ) );
and2_1x_hv (*
integer library_binding = "ether";
integer cds_net_set
[0:1] = { "DVDD","DVSS" };
integer DVDD = "avdd";
integer DVSS
 = "agnd";
 *)
I20 ( .Y( xup ), .B( xsiddq ), .A( net152 ) );

inv_1x_hv (*
integer library_binding = "ether";
integer cds_net_set
[0:1] = { "DVSS","DVDD" };
integer DVSS = "agnd";
integer DVDD
 = "avdd";
 *)
I21 ( .Y( xsiddq ), .A( siddq ) );

blw_dac_inv_eqdelay (*
integer library_binding = "ether";
 *)
I1 ( .dvdd(
avdd ), .dgnd( agnd ), .in( down ), .out( net148 ), .xout( net147 ) );
blw_dac_inv_eqdelay (*
integer library_binding = "ether";
 *)
I0 ( .dvdd(
avdd ), .dgnd( agnd ), .in( up ), .out( net153 ), .xout( net152 ) );

endmodule
