// Verilog-AMS netlist generated by the AMS netlister, version ICOA5.2.51.500.7.
// Cadence Design Systems, Inc.

`include "disciplines.vams"

module trans_ld_tenbt_current_mirror ( pos_in,neg_in,gnd,neg_out,VDD,
pos_out,siddq );

input   pos_in;
input   neg_in;
input   gnd;
output   neg_out;

input   VDD;
output   pos_out;
input   siddq;

parameter Iscale=0;
parameter td=0;
parameter tr=0;
parameter tf=0;

gpdk090_nmos2v #(.ps(43.5u), .m(4 * 28), .as(12.8571p), .l(500n), .pd(40.6u),
 .ad(12p), .w(40u)) (*
integer library_binding = "gpdk090";
integer
passed_mfactor = "m";
 *)
NM2 ( pos_in, pos_in, gnd, gnd );
gpdk090_nmos2v #(.ps(43.7231u), .m(4 * 26), .as(12.9231p), .l(500n), .pd(40.6u),
 .ad(12p), .w(40u)) (*
integer library_binding = "gpdk090";
integer
passed_mfactor = "m";
 *)
NM47 ( net111, pos_in, gnd, gnd );
gpdk090_nmos2v #(.ps(54.675u), .m(1 * 16), .as(16.2p), .l(1u), .pd(48.6u),
 .ad(14.4p), .w(48u)) (*
integer library_binding = "gpdk090";
integer
passed_mfactor = "m";
 *)
NM11 ( pos_out, VDD, net115, gnd );
gpdk090_nmos2v #(.ps(54.675u), .m(1 * 16), .as(16.2p), .l(1u), .pd(48.6u),
 .ad(14.4p), .w(48u)) (*
integer library_binding = "gpdk090";
integer
passed_mfactor = "m";
 *)
NM12 ( pos_out, VDD, net143, gnd );
gpdk090_nmos2v #(.ps(54.675u), .m(1 * 16), .as(16.2p), .l(1u), .pd(48.6u),
 .ad(14.4p), .w(48u)) (*
integer library_binding = "gpdk090";
integer
passed_mfactor = "m";
 *)
NM8 ( pos_out, VDD, net119, gnd );
gpdk090_nmos2v #(.ps(54.675u), .m(1 * 16), .as(16.2p), .l(1u), .pd(48.6u),
 .ad(14.4p), .w(48u)) (*
integer library_binding = "gpdk090";
integer
passed_mfactor = "m";
 *)
NM0 ( pos_out, VDD, net123, gnd );
gpdk090_nmos2v #(.ps(43.7231u), .m(4 * 26), .as(12.9231p), .l(500n), .pd(40.6u),
 .ad(12p), .w(40u)) (*
integer library_binding = "gpdk090";
integer
passed_mfactor = "m";
 *)
NM6 ( net115, neg_in, gnd, gnd );
gpdk090_nmos2v #(.ps(54.675u), .m(1 * 16), .as(16.2p), .l(1u), .pd(48.6u),
 .ad(14.4p), .w(48u)) (*
integer library_binding = "gpdk090";
integer
passed_mfactor = "m";
 *)
NM9 ( neg_out, VDD, net111, gnd );
gpdk090_nmos2v #(.ps(54.675u), .m(1 * 16), .as(16.2p), .l(1u), .pd(48.6u),
 .ad(14.4p), .w(48u)) (*
integer library_binding = "gpdk090";
integer
passed_mfactor = "m";
 *)
NM10 ( neg_out, VDD, net131, gnd );
gpdk090_nmos2v #(.ps(101.2u), .m(1 * 1), .as(30p), .l(500n), .pd(101.2u),
 .ad(30p), .w(50u)) (*
integer library_binding = "gpdk090";
integer
passed_mfactor = "m";
 *)
NM28 ( pos_in, siddq, gnd, gnd );
gpdk090_nmos2v #(.ps(54.675u), .m(1 * 16), .as(16.2p), .l(1u), .pd(48.6u),
 .ad(14.4p), .w(48u)) (*
integer library_binding = "gpdk090";
integer
passed_mfactor = "m";
 *)
NM3 ( neg_out, VDD, net135, gnd );
gpdk090_nmos2v #(.ps(101.2u), .m(1 * 1), .as(30p), .l(500n), .pd(101.2u),
 .ad(30p), .w(50u)) (*
integer library_binding = "gpdk090";
integer
passed_mfactor = "m";
 *)
NM39 ( neg_in, siddq, gnd, gnd );
gpdk090_nmos2v #(.ps(54.675u), .m(1 * 16), .as(16.2p), .l(1u), .pd(48.6u),
 .ad(14.4p), .w(48u)) (*
integer library_binding = "gpdk090";
integer
passed_mfactor = "m";
 *)
NM1 ( neg_out, VDD, net127, gnd );
gpdk090_nmos2v #(.ps(43.7231u), .m(4 * 26), .as(12.9231p), .l(500n), .pd(40.6u),
 .ad(12p), .w(40u)) (*
integer library_binding = "gpdk090";
integer
passed_mfactor = "m";
 *)
NM5 ( net119, neg_in, gnd, gnd );
gpdk090_nmos2v #(.ps(43.7231u), .m(4 * 26), .as(12.9231p), .l(500n), .pd(40.6u),
 .ad(12p), .w(40u)) (*
integer library_binding = "gpdk090";
integer
passed_mfactor = "m";
 *)
NM4 ( net123, neg_in, gnd, gnd );
gpdk090_nmos2v #(.ps(43.7231u), .m(4 * 26), .as(12.9231p), .l(500n), .pd(40.6u),
 .ad(12p), .w(40u)) (*
integer library_binding = "gpdk090";
integer
passed_mfactor = "m";
 *)
NM27 ( net127, pos_in, gnd, gnd );
gpdk090_nmos2v #(.ps(43.7231u), .m(4 * 26), .as(12.9231p), .l(500n), .pd(40.6u),
 .ad(12p), .w(40u)) (*
integer library_binding = "gpdk090";
integer
passed_mfactor = "m";
 *)
NM48 ( net131, pos_in, gnd, gnd );
gpdk090_nmos2v #(.ps(43.7231u), .m(4 * 26), .as(12.9231p), .l(500n), .pd(40.6u),
 .ad(12p), .w(40u)) (*
integer library_binding = "gpdk090";
integer
passed_mfactor = "m";
 *)
NM25 ( net135, pos_in, gnd, gnd );
gpdk090_nmos2v #(.ps(43.5u), .m(4 * 28), .as(12.8571p), .l(500n), .pd(40.6u),
 .ad(12p), .w(40u)) (*
integer library_binding = "gpdk090";
integer
passed_mfactor = "m";
 *)
NM14 ( neg_in, neg_in, gnd, gnd );
gpdk090_nmos2v #(.ps(43.7231u), .m(4 * 26), .as(12.9231p), .l(500n), .pd(40.6u),
 .ad(12p), .w(40u)) (*
integer library_binding = "gpdk090";
integer
passed_mfactor = "m";
 *)
NM7 ( net143, neg_in, gnd, gnd );

endmodule
