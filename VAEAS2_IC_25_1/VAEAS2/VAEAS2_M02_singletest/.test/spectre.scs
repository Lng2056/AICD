// Design cell name: restest
simulator lang=spectre
global 0
//ahdl_include "res1.va"

V0 (net2 0) vsource dc=1
I1 (out 0) resistor r=20
I0 (net2 out) resistor r=20

simulatorOptions options save=all
dc1 dc
