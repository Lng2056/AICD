`include "discipline.h"
`include "constants.h"

// $Date: 1997/08/28 05:55:20 $
// $Revision: 1.1 $
//
//
// Based on the OVI Verilog-A Language Reference Manual, version 1.0 1996
//
//

//--------------------
// diode_simple
//
// -  Diode based on Schockley equation
//
// vanode:	Anode voltage [V,A]
// vcathode:	Cathode voltage [V,A]
//
// INSTANCE parameters
//    is   = saturation current with negative bias [A]
//
// MODEL parameters
//    {none}
//

module diodev(vp, vn);
inout vp, vn;
electrical vp, vn;
parameter real is = 1e-13 from (0:inf);

   real vacross;

   analog begin
      vacross = V(vp, vn);
      I(vp,vn) <+ is * (exp(vacross/$vt) - 1);
   end
endmodule
