ADE simulation setup
Test training_ampTest_1: training/ampTest/schematic, simulator spectre
  Variables: CAP = 0.8p
  Temperature: 27
Run mode: Single Run, Sweeps and Corners
