ADE simulation setup
Test training:ampTest:1: training/ampTest/schematic, simulator spectre
  Variables: CAP = 0.8p
  Temperature: 27
Run mode: Single Run, Sweeps and Corners
