ADE simulation setup
Run mode: Single Run, Sweeps and Corners
Tests:
  training:ampTest:1: training/ampTest/schematic, simulator spectre
    Variables: CAP = 0.8p
