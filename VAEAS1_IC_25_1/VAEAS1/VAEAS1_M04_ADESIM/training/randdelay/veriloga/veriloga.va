// VerilogA for randdelay

`include "constants.h"
`include "discipline.h"

module randdelay (op,ip);
output op;
input ip;
electrical op,ip;
parameter real sd=2.0n;
parameter real gainsd=0.1;
parameter real del=5.0n;
parameter real rise=0.1n;
parameter real thresh=0.5;
parameter integer seed = 23133;

integer vseed;
real randnum,gain,delayed;

analog begin

  @(cross(V(ip)-thresh)) begin
    randnum=$rdist_normal(vseed,0,1);
    randnum=randnum*sd+del;
    gain=$rdist_normal(vseed,0,1)*gainsd+1;
    if(randnum<0) randnum=0.0;
  end

  delayed= transition(V(ip),randnum,rise,rise);

  V(op) <+ gain*(delayed-thresh)+thresh;

end

endmodule
